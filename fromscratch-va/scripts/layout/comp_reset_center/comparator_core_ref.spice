.subckt comparator_core INP INN CLK OUTP OUTN VDD VSS TRKAB
xM4_0 OUTN OUTP y VSS sky130_fd_pr__nfet_01v8 w=2 l=0.15
xM2_0 y INN tail VSS sky130_fd_pr__nfet_01v8_lvt w=4 l=0.15
xM2_1 y INN tail VSS sky130_fd_pr__nfet_01v8_lvt w=4 l=0.15
xMT_0 tail CLK VSS VSS sky130_fd_pr__nfet_01v8 w=4 l=0.15
xM1_0 x INP tail VSS sky130_fd_pr__nfet_01v8_lvt w=4 l=0.15
xM1_1 x INP tail VSS sky130_fd_pr__nfet_01v8_lvt w=4 l=0.15
xM3_0 OUTP OUTN x VSS sky130_fd_pr__nfet_01v8 w=2 l=0.15
xM10_0 VDD CLK y VDD sky130_fd_pr__pfet_01v8 w=1.5 l=0.15
xM8_0 VDD CLK OUTN VDD sky130_fd_pr__pfet_01v8 w=1.5 l=0.15
xM6_0 VDD OUTP OUTN VDD sky130_fd_pr__pfet_01v8 w=3 l=0.15
xMS1_0 INN resetGate VDD VDD sky130_fd_pr__pfet_01v8 w=4.92 l=0.15
xMS1_1 INN resetGate VDD VDD sky130_fd_pr__pfet_01v8 w=4.92 l=0.15
xMS1_2 INN resetGate VDD VDD sky130_fd_pr__pfet_01v8 w=4.92 l=0.15
xMS1_3 INN resetGate VDD VDD sky130_fd_pr__pfet_01v8 w=4.92 l=0.15
xMS1_4 INN resetGate VDD VDD sky130_fd_pr__pfet_01v8 w=4.92 l=0.15
xMS1_5 INN resetGate VDD VDD sky130_fd_pr__pfet_01v8 w=4.92 l=0.15
xMS1_6 INN resetGate VDD VDD sky130_fd_pr__pfet_01v8 w=4.92 l=0.15
xMS1_7 INN resetGate VDD VDD sky130_fd_pr__pfet_01v8 w=4.92 l=0.15
xMS1_8 INN resetGate VDD VDD sky130_fd_pr__pfet_01v8 w=4.92 l=0.15
xMS1_9 INN resetGate VDD VDD sky130_fd_pr__pfet_01v8 w=4.92 l=0.15
xMS1_10 INN resetGate VDD VDD sky130_fd_pr__pfet_01v8 w=4.92 l=0.15
xMS1_11 INN resetGate VDD VDD sky130_fd_pr__pfet_01v8 w=4.92 l=0.15
xMS1_12 INN resetGate VDD VDD sky130_fd_pr__pfet_01v8 w=4.92 l=0.15
xMS1_13 INN resetGate VDD VDD sky130_fd_pr__pfet_01v8 w=4.92 l=0.15
xMS1_14 INN resetGate VDD VDD sky130_fd_pr__pfet_01v8 w=4.92 l=0.15
xMS1_15 INN resetGate VDD VDD sky130_fd_pr__pfet_01v8 w=4.92 l=0.15
xMS1_16 INN resetGate VDD VDD sky130_fd_pr__pfet_01v8 w=4.92 l=0.15
xMS1_17 INN resetGate VDD VDD sky130_fd_pr__pfet_01v8 w=4.92 l=0.15
xMS1_18 INN resetGate VDD VDD sky130_fd_pr__pfet_01v8 w=4.92 l=0.15
xMS1_19 INN resetGate VDD VDD sky130_fd_pr__pfet_01v8 w=4.92 l=0.15
xMS1_20 INN resetGate VDD VDD sky130_fd_pr__pfet_01v8 w=4.92 l=0.15
xMS1_21 INN resetGate VDD VDD sky130_fd_pr__pfet_01v8 w=4.92 l=0.15
xMS1_22 INN resetGate VDD VDD sky130_fd_pr__pfet_01v8 w=4.92 l=0.15
xMS1_23 INN resetGate VDD VDD sky130_fd_pr__pfet_01v8 w=4.92 l=0.15
xMS1_24 INN resetGate VDD VDD sky130_fd_pr__pfet_01v8 w=4.92 l=0.15
xMS1_25 INN resetGate VDD VDD sky130_fd_pr__pfet_01v8 w=4.92 l=0.15
xMS2_0 INP resetGate VDD VDD sky130_fd_pr__pfet_01v8 w=4.92 l=0.15
xMS2_1 INP resetGate VDD VDD sky130_fd_pr__pfet_01v8 w=4.92 l=0.15
xMS2_2 INP resetGate VDD VDD sky130_fd_pr__pfet_01v8 w=4.92 l=0.15
xMS2_3 INP resetGate VDD VDD sky130_fd_pr__pfet_01v8 w=4.92 l=0.15
xMS2_4 INP resetGate VDD VDD sky130_fd_pr__pfet_01v8 w=4.92 l=0.15
xMS2_5 INP resetGate VDD VDD sky130_fd_pr__pfet_01v8 w=4.92 l=0.15
xMS2_6 INP resetGate VDD VDD sky130_fd_pr__pfet_01v8 w=4.92 l=0.15
xMS2_7 INP resetGate VDD VDD sky130_fd_pr__pfet_01v8 w=4.92 l=0.15
xMS2_8 INP resetGate VDD VDD sky130_fd_pr__pfet_01v8 w=4.92 l=0.15
xMS2_9 INP resetGate VDD VDD sky130_fd_pr__pfet_01v8 w=4.92 l=0.15
xMS2_10 INP resetGate VDD VDD sky130_fd_pr__pfet_01v8 w=4.92 l=0.15
xMS2_11 INP resetGate VDD VDD sky130_fd_pr__pfet_01v8 w=4.92 l=0.15
xMS2_12 INP resetGate VDD VDD sky130_fd_pr__pfet_01v8 w=4.92 l=0.15
xMS2_13 INP resetGate VDD VDD sky130_fd_pr__pfet_01v8 w=4.92 l=0.15
xMS2_14 INP resetGate VDD VDD sky130_fd_pr__pfet_01v8 w=4.92 l=0.15
xMS2_15 INP resetGate VDD VDD sky130_fd_pr__pfet_01v8 w=4.92 l=0.15
xMS2_16 INP resetGate VDD VDD sky130_fd_pr__pfet_01v8 w=4.92 l=0.15
xMS2_17 INP resetGate VDD VDD sky130_fd_pr__pfet_01v8 w=4.92 l=0.15
xMS2_18 INP resetGate VDD VDD sky130_fd_pr__pfet_01v8 w=4.92 l=0.15
xMS2_19 INP resetGate VDD VDD sky130_fd_pr__pfet_01v8 w=4.92 l=0.15
xMS2_20 INP resetGate VDD VDD sky130_fd_pr__pfet_01v8 w=4.92 l=0.15
xMS2_21 INP resetGate VDD VDD sky130_fd_pr__pfet_01v8 w=4.92 l=0.15
xMS2_22 INP resetGate VDD VDD sky130_fd_pr__pfet_01v8 w=4.92 l=0.15
xMS2_23 INP resetGate VDD VDD sky130_fd_pr__pfet_01v8 w=4.92 l=0.15
xMS2_24 INP resetGate VDD VDD sky130_fd_pr__pfet_01v8 w=4.92 l=0.15
xMS2_25 INP resetGate VDD VDD sky130_fd_pr__pfet_01v8 w=4.92 l=0.15
xM5_0 VDD OUTN OUTP VDD sky130_fd_pr__pfet_01v8 w=3 l=0.15
xM7_0 VDD CLK OUTP VDD sky130_fd_pr__pfet_01v8 w=1.5 l=0.15
xM9_0 VDD CLK x VDD sky130_fd_pr__pfet_01v8 w=1.5 l=0.15
xBN0_0 resetMid TRKAB VSS VSS sky130_fd_pr__nfet_01v8 w=4 l=0.15
xBP0_0 resetMid TRKAB VDD VDD sky130_fd_pr__pfet_01v8 w=4 l=0.15
xBP0_1 resetMid TRKAB VDD VDD sky130_fd_pr__pfet_01v8 w=4 l=0.15
xBN1_0 resetGate resetMid VSS VSS sky130_fd_pr__nfet_01v8 w=4 l=0.15
xBN1_1 resetGate resetMid VSS VSS sky130_fd_pr__nfet_01v8 w=4 l=0.15
xBP1_0 resetGate resetMid VDD VDD sky130_fd_pr__pfet_01v8 w=4 l=0.15
xBP1_1 resetGate resetMid VDD VDD sky130_fd_pr__pfet_01v8 w=4 l=0.15
xBP1_2 resetGate resetMid VDD VDD sky130_fd_pr__pfet_01v8 w=4 l=0.15
xBP1_3 resetGate resetMid VDD VDD sky130_fd_pr__pfet_01v8 w=4 l=0.15
xcy y VSS sky130_fd_pr__cap_mim_m3_1 w=7.07 l=7.07
xcx x VSS sky130_fd_pr__cap_mim_m3_1 w=7.07 l=7.07
xco1 OUTN VSS sky130_fd_pr__cap_mim_m3_1 w=3.23 l=3.23
xco2 OUTP VSS sky130_fd_pr__cap_mim_m3_1 w=3.16 l=3.16
.ends comparator_core
