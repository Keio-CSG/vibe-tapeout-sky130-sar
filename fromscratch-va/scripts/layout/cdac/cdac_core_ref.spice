.subckt cdac_core TOP VSS B0 B1 B2 B3 B4 B5 B6 B7 B8 B9 B10
xc_0_0 VSS VSS sky130_fd_pr__cap_mim_m3_1 w=1.24 l=1.24
xc_1_0 VSS VSS sky130_fd_pr__cap_mim_m3_1 w=1.24 l=1.24
xc_2_0 VSS VSS sky130_fd_pr__cap_mim_m3_1 w=1.24 l=1.24
xc_3_0 VSS VSS sky130_fd_pr__cap_mim_m3_1 w=1.24 l=1.24
xc_4_0 VSS VSS sky130_fd_pr__cap_mim_m3_1 w=1.24 l=1.24
xc_5_0 VSS VSS sky130_fd_pr__cap_mim_m3_1 w=1.24 l=1.24
xc_6_0 VSS VSS sky130_fd_pr__cap_mim_m3_1 w=1.24 l=1.24
xc_7_0 VSS VSS sky130_fd_pr__cap_mim_m3_1 w=1.24 l=1.24
xc_8_0 VSS VSS sky130_fd_pr__cap_mim_m3_1 w=1.24 l=1.24
xc_9_0 VSS VSS sky130_fd_pr__cap_mim_m3_1 w=1.24 l=1.24
xc_10_0 VSS VSS sky130_fd_pr__cap_mim_m3_1 w=1.24 l=1.24
xc_11_0 VSS VSS sky130_fd_pr__cap_mim_m3_1 w=1.24 l=1.24
xc_12_0 VSS VSS sky130_fd_pr__cap_mim_m3_1 w=1.24 l=1.24
xc_13_0 VSS VSS sky130_fd_pr__cap_mim_m3_1 w=1.24 l=1.24
xc_14_0 VSS VSS sky130_fd_pr__cap_mim_m3_1 w=1.24 l=1.24
xc_15_0 VSS VSS sky130_fd_pr__cap_mim_m3_1 w=1.24 l=1.24
xc_16_0 VSS VSS sky130_fd_pr__cap_mim_m3_1 w=1.24 l=1.24
xc_17_0 VSS VSS sky130_fd_pr__cap_mim_m3_1 w=1.24 l=1.24
xc_18_0 VSS VSS sky130_fd_pr__cap_mim_m3_1 w=1.24 l=1.24
xc_19_0 VSS VSS sky130_fd_pr__cap_mim_m3_1 w=1.24 l=1.24
xc_20_0 VSS VSS sky130_fd_pr__cap_mim_m3_1 w=1.24 l=1.24
xc_21_0 VSS VSS sky130_fd_pr__cap_mim_m3_1 w=1.24 l=1.24
xc_22_0 VSS VSS sky130_fd_pr__cap_mim_m3_1 w=1.24 l=1.24
xc_23_0 VSS VSS sky130_fd_pr__cap_mim_m3_1 w=1.24 l=1.24
xc_24_0 VSS VSS sky130_fd_pr__cap_mim_m3_1 w=1.24 l=1.24
xc_25_0 VSS VSS sky130_fd_pr__cap_mim_m3_1 w=1.24 l=1.24
xc_26_0 VSS VSS sky130_fd_pr__cap_mim_m3_1 w=1.24 l=1.24
xc_27_0 VSS VSS sky130_fd_pr__cap_mim_m3_1 w=1.24 l=1.24
xc_28_0 VSS VSS sky130_fd_pr__cap_mim_m3_1 w=1.24 l=1.24
xc_29_0 VSS VSS sky130_fd_pr__cap_mim_m3_1 w=1.24 l=1.24
xc_30_0 VSS VSS sky130_fd_pr__cap_mim_m3_1 w=1.24 l=1.24
xc_31_0 VSS VSS sky130_fd_pr__cap_mim_m3_1 w=1.24 l=1.24
xc_32_0 VSS VSS sky130_fd_pr__cap_mim_m3_1 w=1.24 l=1.24
xc_33_0 VSS VSS sky130_fd_pr__cap_mim_m3_1 w=1.24 l=1.24
xc_0_1 VSS VSS sky130_fd_pr__cap_mim_m3_1 w=1.24 l=1.24
xc_1_1 TOP B0 sky130_fd_pr__cap_mim_m3_1 w=1.24 l=1.24
xc_2_1 TOP B0 sky130_fd_pr__cap_mim_m3_1 w=1.24 l=1.24
xc_3_1 TOP B0 sky130_fd_pr__cap_mim_m3_1 w=1.24 l=1.24
xc_4_1 TOP B0 sky130_fd_pr__cap_mim_m3_1 w=1.24 l=1.24
xc_5_1 TOP B0 sky130_fd_pr__cap_mim_m3_1 w=1.24 l=1.24
xc_6_1 TOP B0 sky130_fd_pr__cap_mim_m3_1 w=1.24 l=1.24
xc_7_1 TOP B0 sky130_fd_pr__cap_mim_m3_1 w=1.24 l=1.24
xc_8_1 TOP B0 sky130_fd_pr__cap_mim_m3_1 w=1.24 l=1.24
xc_9_1 TOP B1 sky130_fd_pr__cap_mim_m3_1 w=1.24 l=1.24
xc_10_1 TOP B1 sky130_fd_pr__cap_mim_m3_1 w=1.24 l=1.24
xc_11_1 TOP B1 sky130_fd_pr__cap_mim_m3_1 w=1.24 l=1.24
xc_12_1 TOP B1 sky130_fd_pr__cap_mim_m3_1 w=1.24 l=1.24
xc_13_1 TOP B2 sky130_fd_pr__cap_mim_m3_1 w=1.24 l=1.24
xc_14_1 TOP B2 sky130_fd_pr__cap_mim_m3_1 w=1.24 l=1.24
xc_15_1 TOP B3 sky130_fd_pr__cap_mim_m3_1 w=1.24 l=1.24
xc_16_1 TOP B4 sky130_fd_pr__cap_mim_m3_1 w=1.24 l=1.24
xc_17_1 TOP B4 sky130_fd_pr__cap_mim_m3_1 w=1.24 l=1.24
xc_18_1 TOP B3 sky130_fd_pr__cap_mim_m3_1 w=1.24 l=1.24
xc_19_1 TOP B2 sky130_fd_pr__cap_mim_m3_1 w=1.24 l=1.24
xc_20_1 TOP B2 sky130_fd_pr__cap_mim_m3_1 w=1.24 l=1.24
xc_21_1 TOP B1 sky130_fd_pr__cap_mim_m3_1 w=1.24 l=1.24
xc_22_1 TOP B1 sky130_fd_pr__cap_mim_m3_1 w=1.24 l=1.24
xc_23_1 TOP B1 sky130_fd_pr__cap_mim_m3_1 w=1.24 l=1.24
xc_24_1 TOP B1 sky130_fd_pr__cap_mim_m3_1 w=1.24 l=1.24
xc_25_1 TOP B0 sky130_fd_pr__cap_mim_m3_1 w=1.24 l=1.24
xc_26_1 TOP B0 sky130_fd_pr__cap_mim_m3_1 w=1.24 l=1.24
xc_27_1 TOP B0 sky130_fd_pr__cap_mim_m3_1 w=1.24 l=1.24
xc_28_1 TOP B0 sky130_fd_pr__cap_mim_m3_1 w=1.24 l=1.24
xc_29_1 TOP B0 sky130_fd_pr__cap_mim_m3_1 w=1.24 l=1.24
xc_30_1 TOP B0 sky130_fd_pr__cap_mim_m3_1 w=1.24 l=1.24
xc_31_1 TOP B0 sky130_fd_pr__cap_mim_m3_1 w=1.24 l=1.24
xc_32_1 TOP B0 sky130_fd_pr__cap_mim_m3_1 w=1.24 l=1.24
xc_33_1 VSS VSS sky130_fd_pr__cap_mim_m3_1 w=1.24 l=1.24
xc_0_2 VSS VSS sky130_fd_pr__cap_mim_m3_1 w=1.24 l=1.24
xc_1_2 TOP B0 sky130_fd_pr__cap_mim_m3_1 w=1.24 l=1.24
xc_2_2 TOP B0 sky130_fd_pr__cap_mim_m3_1 w=1.24 l=1.24
xc_3_2 TOP B0 sky130_fd_pr__cap_mim_m3_1 w=1.24 l=1.24
xc_4_2 TOP B0 sky130_fd_pr__cap_mim_m3_1 w=1.24 l=1.24
xc_5_2 TOP B0 sky130_fd_pr__cap_mim_m3_1 w=1.24 l=1.24
xc_6_2 TOP B0 sky130_fd_pr__cap_mim_m3_1 w=1.24 l=1.24
xc_7_2 TOP B0 sky130_fd_pr__cap_mim_m3_1 w=1.24 l=1.24
xc_8_2 TOP B0 sky130_fd_pr__cap_mim_m3_1 w=1.24 l=1.24
xc_9_2 TOP B1 sky130_fd_pr__cap_mim_m3_1 w=1.24 l=1.24
xc_10_2 TOP B1 sky130_fd_pr__cap_mim_m3_1 w=1.24 l=1.24
xc_11_2 TOP B1 sky130_fd_pr__cap_mim_m3_1 w=1.24 l=1.24
xc_12_2 TOP B1 sky130_fd_pr__cap_mim_m3_1 w=1.24 l=1.24
xc_13_2 TOP B2 sky130_fd_pr__cap_mim_m3_1 w=1.24 l=1.24
xc_14_2 TOP B2 sky130_fd_pr__cap_mim_m3_1 w=1.24 l=1.24
xc_15_2 TOP B3 sky130_fd_pr__cap_mim_m3_1 w=1.24 l=1.24
xc_16_2 TOP B4 sky130_fd_pr__cap_mim_m3_1 w=1.24 l=1.24
xc_17_2 TOP B4 sky130_fd_pr__cap_mim_m3_1 w=1.24 l=1.24
xc_18_2 TOP B3 sky130_fd_pr__cap_mim_m3_1 w=1.24 l=1.24
xc_19_2 TOP B2 sky130_fd_pr__cap_mim_m3_1 w=1.24 l=1.24
xc_20_2 TOP B2 sky130_fd_pr__cap_mim_m3_1 w=1.24 l=1.24
xc_21_2 TOP B1 sky130_fd_pr__cap_mim_m3_1 w=1.24 l=1.24
xc_22_2 TOP B1 sky130_fd_pr__cap_mim_m3_1 w=1.24 l=1.24
xc_23_2 TOP B1 sky130_fd_pr__cap_mim_m3_1 w=1.24 l=1.24
xc_24_2 TOP B1 sky130_fd_pr__cap_mim_m3_1 w=1.24 l=1.24
xc_25_2 TOP B0 sky130_fd_pr__cap_mim_m3_1 w=1.24 l=1.24
xc_26_2 TOP B0 sky130_fd_pr__cap_mim_m3_1 w=1.24 l=1.24
xc_27_2 TOP B0 sky130_fd_pr__cap_mim_m3_1 w=1.24 l=1.24
xc_28_2 TOP B0 sky130_fd_pr__cap_mim_m3_1 w=1.24 l=1.24
xc_29_2 TOP B0 sky130_fd_pr__cap_mim_m3_1 w=1.24 l=1.24
xc_30_2 TOP B0 sky130_fd_pr__cap_mim_m3_1 w=1.24 l=1.24
xc_31_2 TOP B0 sky130_fd_pr__cap_mim_m3_1 w=1.24 l=1.24
xc_32_2 TOP B0 sky130_fd_pr__cap_mim_m3_1 w=1.24 l=1.24
xc_33_2 VSS VSS sky130_fd_pr__cap_mim_m3_1 w=1.24 l=1.24
xc_0_3 VSS VSS sky130_fd_pr__cap_mim_m3_1 w=1.24 l=1.24
xc_1_3 TOP B0 sky130_fd_pr__cap_mim_m3_1 w=1.24 l=1.24
xc_2_3 TOP B0 sky130_fd_pr__cap_mim_m3_1 w=1.24 l=1.24
xc_3_3 TOP B0 sky130_fd_pr__cap_mim_m3_1 w=1.24 l=1.24
xc_4_3 TOP B0 sky130_fd_pr__cap_mim_m3_1 w=1.24 l=1.24
xc_5_3 TOP B0 sky130_fd_pr__cap_mim_m3_1 w=1.24 l=1.24
xc_6_3 TOP B0 sky130_fd_pr__cap_mim_m3_1 w=1.24 l=1.24
xc_7_3 TOP B0 sky130_fd_pr__cap_mim_m3_1 w=1.24 l=1.24
xc_8_3 TOP B0 sky130_fd_pr__cap_mim_m3_1 w=1.24 l=1.24
xc_9_3 TOP B1 sky130_fd_pr__cap_mim_m3_1 w=1.24 l=1.24
xc_10_3 TOP B1 sky130_fd_pr__cap_mim_m3_1 w=1.24 l=1.24
xc_11_3 TOP B1 sky130_fd_pr__cap_mim_m3_1 w=1.24 l=1.24
xc_12_3 TOP B1 sky130_fd_pr__cap_mim_m3_1 w=1.24 l=1.24
xc_13_3 TOP B2 sky130_fd_pr__cap_mim_m3_1 w=1.24 l=1.24
xc_14_3 TOP B2 sky130_fd_pr__cap_mim_m3_1 w=1.24 l=1.24
xc_15_3 TOP B3 sky130_fd_pr__cap_mim_m3_1 w=1.24 l=1.24
xc_16_3 TOP B4 sky130_fd_pr__cap_mim_m3_1 w=1.24 l=1.24
xc_17_3 TOP B4 sky130_fd_pr__cap_mim_m3_1 w=1.24 l=1.24
xc_18_3 TOP B3 sky130_fd_pr__cap_mim_m3_1 w=1.24 l=1.24
xc_19_3 TOP B2 sky130_fd_pr__cap_mim_m3_1 w=1.24 l=1.24
xc_20_3 TOP B2 sky130_fd_pr__cap_mim_m3_1 w=1.24 l=1.24
xc_21_3 TOP B1 sky130_fd_pr__cap_mim_m3_1 w=1.24 l=1.24
xc_22_3 TOP B1 sky130_fd_pr__cap_mim_m3_1 w=1.24 l=1.24
xc_23_3 TOP B1 sky130_fd_pr__cap_mim_m3_1 w=1.24 l=1.24
xc_24_3 TOP B1 sky130_fd_pr__cap_mim_m3_1 w=1.24 l=1.24
xc_25_3 TOP B0 sky130_fd_pr__cap_mim_m3_1 w=1.24 l=1.24
xc_26_3 TOP B0 sky130_fd_pr__cap_mim_m3_1 w=1.24 l=1.24
xc_27_3 TOP B0 sky130_fd_pr__cap_mim_m3_1 w=1.24 l=1.24
xc_28_3 TOP B0 sky130_fd_pr__cap_mim_m3_1 w=1.24 l=1.24
xc_29_3 TOP B0 sky130_fd_pr__cap_mim_m3_1 w=1.24 l=1.24
xc_30_3 TOP B0 sky130_fd_pr__cap_mim_m3_1 w=1.24 l=1.24
xc_31_3 TOP B0 sky130_fd_pr__cap_mim_m3_1 w=1.24 l=1.24
xc_32_3 TOP B0 sky130_fd_pr__cap_mim_m3_1 w=1.24 l=1.24
xc_33_3 VSS VSS sky130_fd_pr__cap_mim_m3_1 w=1.24 l=1.24
xc_0_4 VSS VSS sky130_fd_pr__cap_mim_m3_1 w=1.24 l=1.24
xc_1_4 TOP B0 sky130_fd_pr__cap_mim_m3_1 w=1.24 l=1.24
xc_2_4 TOP B0 sky130_fd_pr__cap_mim_m3_1 w=1.24 l=1.24
xc_3_4 TOP B0 sky130_fd_pr__cap_mim_m3_1 w=1.24 l=1.24
xc_4_4 TOP B0 sky130_fd_pr__cap_mim_m3_1 w=1.24 l=1.24
xc_5_4 TOP B0 sky130_fd_pr__cap_mim_m3_1 w=1.24 l=1.24
xc_6_4 TOP B0 sky130_fd_pr__cap_mim_m3_1 w=1.24 l=1.24
xc_7_4 TOP B0 sky130_fd_pr__cap_mim_m3_1 w=1.24 l=1.24
xc_8_4 TOP B0 sky130_fd_pr__cap_mim_m3_1 w=1.24 l=1.24
xc_9_4 TOP B1 sky130_fd_pr__cap_mim_m3_1 w=1.24 l=1.24
xc_10_4 TOP B1 sky130_fd_pr__cap_mim_m3_1 w=1.24 l=1.24
xc_11_4 TOP B1 sky130_fd_pr__cap_mim_m3_1 w=1.24 l=1.24
xc_12_4 TOP B1 sky130_fd_pr__cap_mim_m3_1 w=1.24 l=1.24
xc_13_4 TOP B2 sky130_fd_pr__cap_mim_m3_1 w=1.24 l=1.24
xc_14_4 TOP B2 sky130_fd_pr__cap_mim_m3_1 w=1.24 l=1.24
xc_15_4 TOP B3 sky130_fd_pr__cap_mim_m3_1 w=1.24 l=1.24
xc_16_4 TOP B4 sky130_fd_pr__cap_mim_m3_1 w=1.24 l=1.24
xc_17_4 TOP B4 sky130_fd_pr__cap_mim_m3_1 w=1.24 l=1.24
xc_18_4 TOP B3 sky130_fd_pr__cap_mim_m3_1 w=1.24 l=1.24
xc_19_4 TOP B2 sky130_fd_pr__cap_mim_m3_1 w=1.24 l=1.24
xc_20_4 TOP B2 sky130_fd_pr__cap_mim_m3_1 w=1.24 l=1.24
xc_21_4 TOP B1 sky130_fd_pr__cap_mim_m3_1 w=1.24 l=1.24
xc_22_4 TOP B1 sky130_fd_pr__cap_mim_m3_1 w=1.24 l=1.24
xc_23_4 TOP B1 sky130_fd_pr__cap_mim_m3_1 w=1.24 l=1.24
xc_24_4 TOP B1 sky130_fd_pr__cap_mim_m3_1 w=1.24 l=1.24
xc_25_4 TOP B0 sky130_fd_pr__cap_mim_m3_1 w=1.24 l=1.24
xc_26_4 TOP B0 sky130_fd_pr__cap_mim_m3_1 w=1.24 l=1.24
xc_27_4 TOP B0 sky130_fd_pr__cap_mim_m3_1 w=1.24 l=1.24
xc_28_4 TOP B0 sky130_fd_pr__cap_mim_m3_1 w=1.24 l=1.24
xc_29_4 TOP B0 sky130_fd_pr__cap_mim_m3_1 w=1.24 l=1.24
xc_30_4 TOP B0 sky130_fd_pr__cap_mim_m3_1 w=1.24 l=1.24
xc_31_4 TOP B0 sky130_fd_pr__cap_mim_m3_1 w=1.24 l=1.24
xc_32_4 TOP B0 sky130_fd_pr__cap_mim_m3_1 w=1.24 l=1.24
xc_33_4 VSS VSS sky130_fd_pr__cap_mim_m3_1 w=1.24 l=1.24
xc_0_5 VSS VSS sky130_fd_pr__cap_mim_m3_1 w=1.24 l=1.24
xc_1_5 TOP B0 sky130_fd_pr__cap_mim_m3_1 w=1.24 l=1.24
xc_2_5 TOP B0 sky130_fd_pr__cap_mim_m3_1 w=1.24 l=1.24
xc_3_5 TOP B0 sky130_fd_pr__cap_mim_m3_1 w=1.24 l=1.24
xc_4_5 TOP B0 sky130_fd_pr__cap_mim_m3_1 w=1.24 l=1.24
xc_5_5 TOP B0 sky130_fd_pr__cap_mim_m3_1 w=1.24 l=1.24
xc_6_5 TOP B0 sky130_fd_pr__cap_mim_m3_1 w=1.24 l=1.24
xc_7_5 TOP B0 sky130_fd_pr__cap_mim_m3_1 w=1.24 l=1.24
xc_8_5 TOP B0 sky130_fd_pr__cap_mim_m3_1 w=1.24 l=1.24
xc_9_5 TOP B1 sky130_fd_pr__cap_mim_m3_1 w=1.24 l=1.24
xc_10_5 TOP B1 sky130_fd_pr__cap_mim_m3_1 w=1.24 l=1.24
xc_11_5 TOP B1 sky130_fd_pr__cap_mim_m3_1 w=1.24 l=1.24
xc_12_5 TOP B1 sky130_fd_pr__cap_mim_m3_1 w=1.24 l=1.24
xc_13_5 TOP B2 sky130_fd_pr__cap_mim_m3_1 w=1.24 l=1.24
xc_14_5 TOP B2 sky130_fd_pr__cap_mim_m3_1 w=1.24 l=1.24
xc_15_5 TOP B3 sky130_fd_pr__cap_mim_m3_1 w=1.24 l=1.24
xc_16_5 TOP B4 sky130_fd_pr__cap_mim_m3_1 w=1.24 l=1.24
xc_17_5 TOP B4 sky130_fd_pr__cap_mim_m3_1 w=1.24 l=1.24
xc_18_5 TOP B3 sky130_fd_pr__cap_mim_m3_1 w=1.24 l=1.24
xc_19_5 TOP B2 sky130_fd_pr__cap_mim_m3_1 w=1.24 l=1.24
xc_20_5 TOP B2 sky130_fd_pr__cap_mim_m3_1 w=1.24 l=1.24
xc_21_5 TOP B1 sky130_fd_pr__cap_mim_m3_1 w=1.24 l=1.24
xc_22_5 TOP B1 sky130_fd_pr__cap_mim_m3_1 w=1.24 l=1.24
xc_23_5 TOP B1 sky130_fd_pr__cap_mim_m3_1 w=1.24 l=1.24
xc_24_5 TOP B1 sky130_fd_pr__cap_mim_m3_1 w=1.24 l=1.24
xc_25_5 TOP B0 sky130_fd_pr__cap_mim_m3_1 w=1.24 l=1.24
xc_26_5 TOP B0 sky130_fd_pr__cap_mim_m3_1 w=1.24 l=1.24
xc_27_5 TOP B0 sky130_fd_pr__cap_mim_m3_1 w=1.24 l=1.24
xc_28_5 TOP B0 sky130_fd_pr__cap_mim_m3_1 w=1.24 l=1.24
xc_29_5 TOP B0 sky130_fd_pr__cap_mim_m3_1 w=1.24 l=1.24
xc_30_5 TOP B0 sky130_fd_pr__cap_mim_m3_1 w=1.24 l=1.24
xc_31_5 TOP B0 sky130_fd_pr__cap_mim_m3_1 w=1.24 l=1.24
xc_32_5 TOP B0 sky130_fd_pr__cap_mim_m3_1 w=1.24 l=1.24
xc_33_5 VSS VSS sky130_fd_pr__cap_mim_m3_1 w=1.24 l=1.24
xc_0_6 VSS VSS sky130_fd_pr__cap_mim_m3_1 w=1.24 l=1.24
xc_1_6 TOP B0 sky130_fd_pr__cap_mim_m3_1 w=1.24 l=1.24
xc_2_6 TOP B0 sky130_fd_pr__cap_mim_m3_1 w=1.24 l=1.24
xc_3_6 TOP B0 sky130_fd_pr__cap_mim_m3_1 w=1.24 l=1.24
xc_4_6 TOP B0 sky130_fd_pr__cap_mim_m3_1 w=1.24 l=1.24
xc_5_6 TOP B0 sky130_fd_pr__cap_mim_m3_1 w=1.24 l=1.24
xc_6_6 TOP B0 sky130_fd_pr__cap_mim_m3_1 w=1.24 l=1.24
xc_7_6 TOP B0 sky130_fd_pr__cap_mim_m3_1 w=1.24 l=1.24
xc_8_6 TOP B0 sky130_fd_pr__cap_mim_m3_1 w=1.24 l=1.24
xc_9_6 TOP B1 sky130_fd_pr__cap_mim_m3_1 w=1.24 l=1.24
xc_10_6 TOP B1 sky130_fd_pr__cap_mim_m3_1 w=1.24 l=1.24
xc_11_6 TOP B1 sky130_fd_pr__cap_mim_m3_1 w=1.24 l=1.24
xc_12_6 TOP B1 sky130_fd_pr__cap_mim_m3_1 w=1.24 l=1.24
xc_13_6 TOP B2 sky130_fd_pr__cap_mim_m3_1 w=1.24 l=1.24
xc_14_6 TOP B2 sky130_fd_pr__cap_mim_m3_1 w=1.24 l=1.24
xc_15_6 TOP B3 sky130_fd_pr__cap_mim_m3_1 w=1.24 l=1.24
xc_16_6 TOP B4 sky130_fd_pr__cap_mim_m3_1 w=1.24 l=1.24
xc_17_6 TOP B4 sky130_fd_pr__cap_mim_m3_1 w=1.24 l=1.24
xc_18_6 TOP B3 sky130_fd_pr__cap_mim_m3_1 w=1.24 l=1.24
xc_19_6 TOP B2 sky130_fd_pr__cap_mim_m3_1 w=1.24 l=1.24
xc_20_6 TOP B2 sky130_fd_pr__cap_mim_m3_1 w=1.24 l=1.24
xc_21_6 TOP B1 sky130_fd_pr__cap_mim_m3_1 w=1.24 l=1.24
xc_22_6 TOP B1 sky130_fd_pr__cap_mim_m3_1 w=1.24 l=1.24
xc_23_6 TOP B1 sky130_fd_pr__cap_mim_m3_1 w=1.24 l=1.24
xc_24_6 TOP B1 sky130_fd_pr__cap_mim_m3_1 w=1.24 l=1.24
xc_25_6 TOP B0 sky130_fd_pr__cap_mim_m3_1 w=1.24 l=1.24
xc_26_6 TOP B0 sky130_fd_pr__cap_mim_m3_1 w=1.24 l=1.24
xc_27_6 TOP B0 sky130_fd_pr__cap_mim_m3_1 w=1.24 l=1.24
xc_28_6 TOP B0 sky130_fd_pr__cap_mim_m3_1 w=1.24 l=1.24
xc_29_6 TOP B0 sky130_fd_pr__cap_mim_m3_1 w=1.24 l=1.24
xc_30_6 TOP B0 sky130_fd_pr__cap_mim_m3_1 w=1.24 l=1.24
xc_31_6 TOP B0 sky130_fd_pr__cap_mim_m3_1 w=1.24 l=1.24
xc_32_6 TOP B0 sky130_fd_pr__cap_mim_m3_1 w=1.24 l=1.24
xc_33_6 VSS VSS sky130_fd_pr__cap_mim_m3_1 w=1.24 l=1.24
xc_0_7 VSS VSS sky130_fd_pr__cap_mim_m3_1 w=1.24 l=1.24
xc_1_7 TOP B0 sky130_fd_pr__cap_mim_m3_1 w=1.24 l=1.24
xc_2_7 TOP B0 sky130_fd_pr__cap_mim_m3_1 w=1.24 l=1.24
xc_3_7 TOP B0 sky130_fd_pr__cap_mim_m3_1 w=1.24 l=1.24
xc_4_7 TOP B0 sky130_fd_pr__cap_mim_m3_1 w=1.24 l=1.24
xc_5_7 TOP B0 sky130_fd_pr__cap_mim_m3_1 w=1.24 l=1.24
xc_6_7 TOP B0 sky130_fd_pr__cap_mim_m3_1 w=1.24 l=1.24
xc_7_7 TOP B0 sky130_fd_pr__cap_mim_m3_1 w=1.24 l=1.24
xc_8_7 TOP B0 sky130_fd_pr__cap_mim_m3_1 w=1.24 l=1.24
xc_9_7 TOP B1 sky130_fd_pr__cap_mim_m3_1 w=1.24 l=1.24
xc_10_7 TOP B1 sky130_fd_pr__cap_mim_m3_1 w=1.24 l=1.24
xc_11_7 TOP B1 sky130_fd_pr__cap_mim_m3_1 w=1.24 l=1.24
xc_12_7 TOP B1 sky130_fd_pr__cap_mim_m3_1 w=1.24 l=1.24
xc_13_7 TOP B2 sky130_fd_pr__cap_mim_m3_1 w=1.24 l=1.24
xc_14_7 TOP B2 sky130_fd_pr__cap_mim_m3_1 w=1.24 l=1.24
xc_15_7 TOP B3 sky130_fd_pr__cap_mim_m3_1 w=1.24 l=1.24
xc_16_7 TOP B4 sky130_fd_pr__cap_mim_m3_1 w=1.24 l=1.24
xc_17_7 TOP B4 sky130_fd_pr__cap_mim_m3_1 w=1.24 l=1.24
xc_18_7 TOP B3 sky130_fd_pr__cap_mim_m3_1 w=1.24 l=1.24
xc_19_7 TOP B2 sky130_fd_pr__cap_mim_m3_1 w=1.24 l=1.24
xc_20_7 TOP B2 sky130_fd_pr__cap_mim_m3_1 w=1.24 l=1.24
xc_21_7 TOP B1 sky130_fd_pr__cap_mim_m3_1 w=1.24 l=1.24
xc_22_7 TOP B1 sky130_fd_pr__cap_mim_m3_1 w=1.24 l=1.24
xc_23_7 TOP B1 sky130_fd_pr__cap_mim_m3_1 w=1.24 l=1.24
xc_24_7 TOP B1 sky130_fd_pr__cap_mim_m3_1 w=1.24 l=1.24
xc_25_7 TOP B0 sky130_fd_pr__cap_mim_m3_1 w=1.24 l=1.24
xc_26_7 TOP B0 sky130_fd_pr__cap_mim_m3_1 w=1.24 l=1.24
xc_27_7 TOP B0 sky130_fd_pr__cap_mim_m3_1 w=1.24 l=1.24
xc_28_7 TOP B0 sky130_fd_pr__cap_mim_m3_1 w=1.24 l=1.24
xc_29_7 TOP B0 sky130_fd_pr__cap_mim_m3_1 w=1.24 l=1.24
xc_30_7 TOP B0 sky130_fd_pr__cap_mim_m3_1 w=1.24 l=1.24
xc_31_7 TOP B0 sky130_fd_pr__cap_mim_m3_1 w=1.24 l=1.24
xc_32_7 TOP B0 sky130_fd_pr__cap_mim_m3_1 w=1.24 l=1.24
xc_33_7 VSS VSS sky130_fd_pr__cap_mim_m3_1 w=1.24 l=1.24
xc_0_8 VSS VSS sky130_fd_pr__cap_mim_m3_1 w=1.24 l=1.24
xc_1_8 TOP B0 sky130_fd_pr__cap_mim_m3_1 w=1.24 l=1.24
xc_2_8 TOP B0 sky130_fd_pr__cap_mim_m3_1 w=1.24 l=1.24
xc_3_8 TOP B0 sky130_fd_pr__cap_mim_m3_1 w=1.24 l=1.24
xc_4_8 TOP B0 sky130_fd_pr__cap_mim_m3_1 w=1.24 l=1.24
xc_5_8 TOP B0 sky130_fd_pr__cap_mim_m3_1 w=1.24 l=1.24
xc_6_8 TOP B0 sky130_fd_pr__cap_mim_m3_1 w=1.24 l=1.24
xc_7_8 TOP B0 sky130_fd_pr__cap_mim_m3_1 w=1.24 l=1.24
xc_8_8 TOP B0 sky130_fd_pr__cap_mim_m3_1 w=1.24 l=1.24
xc_9_8 TOP B1 sky130_fd_pr__cap_mim_m3_1 w=1.24 l=1.24
xc_10_8 TOP B1 sky130_fd_pr__cap_mim_m3_1 w=1.24 l=1.24
xc_11_8 TOP B1 sky130_fd_pr__cap_mim_m3_1 w=1.24 l=1.24
xc_12_8 TOP B1 sky130_fd_pr__cap_mim_m3_1 w=1.24 l=1.24
xc_13_8 TOP B2 sky130_fd_pr__cap_mim_m3_1 w=1.24 l=1.24
xc_14_8 TOP B2 sky130_fd_pr__cap_mim_m3_1 w=1.24 l=1.24
xc_15_8 TOP B3 sky130_fd_pr__cap_mim_m3_1 w=1.24 l=1.24
xc_16_8 TOP B4 sky130_fd_pr__cap_mim_m3_1 w=1.24 l=1.24
xc_17_8 TOP B4 sky130_fd_pr__cap_mim_m3_1 w=1.24 l=1.24
xc_18_8 TOP B3 sky130_fd_pr__cap_mim_m3_1 w=1.24 l=1.24
xc_19_8 TOP B2 sky130_fd_pr__cap_mim_m3_1 w=1.24 l=1.24
xc_20_8 TOP B2 sky130_fd_pr__cap_mim_m3_1 w=1.24 l=1.24
xc_21_8 TOP B1 sky130_fd_pr__cap_mim_m3_1 w=1.24 l=1.24
xc_22_8 TOP B1 sky130_fd_pr__cap_mim_m3_1 w=1.24 l=1.24
xc_23_8 TOP B1 sky130_fd_pr__cap_mim_m3_1 w=1.24 l=1.24
xc_24_8 TOP B1 sky130_fd_pr__cap_mim_m3_1 w=1.24 l=1.24
xc_25_8 TOP B0 sky130_fd_pr__cap_mim_m3_1 w=1.24 l=1.24
xc_26_8 TOP B0 sky130_fd_pr__cap_mim_m3_1 w=1.24 l=1.24
xc_27_8 TOP B0 sky130_fd_pr__cap_mim_m3_1 w=1.24 l=1.24
xc_28_8 TOP B0 sky130_fd_pr__cap_mim_m3_1 w=1.24 l=1.24
xc_29_8 TOP B0 sky130_fd_pr__cap_mim_m3_1 w=1.24 l=1.24
xc_30_8 TOP B0 sky130_fd_pr__cap_mim_m3_1 w=1.24 l=1.24
xc_31_8 TOP B0 sky130_fd_pr__cap_mim_m3_1 w=1.24 l=1.24
xc_32_8 TOP B0 sky130_fd_pr__cap_mim_m3_1 w=1.24 l=1.24
xc_33_8 VSS VSS sky130_fd_pr__cap_mim_m3_1 w=1.24 l=1.24
xc_0_9 VSS VSS sky130_fd_pr__cap_mim_m3_1 w=1.24 l=1.24
xc_1_9 TOP B0 sky130_fd_pr__cap_mim_m3_1 w=1.24 l=1.24
xc_2_9 TOP B0 sky130_fd_pr__cap_mim_m3_1 w=1.24 l=1.24
xc_3_9 TOP B0 sky130_fd_pr__cap_mim_m3_1 w=1.24 l=1.24
xc_4_9 TOP B0 sky130_fd_pr__cap_mim_m3_1 w=1.24 l=1.24
xc_5_9 TOP B0 sky130_fd_pr__cap_mim_m3_1 w=1.24 l=1.24
xc_6_9 TOP B0 sky130_fd_pr__cap_mim_m3_1 w=1.24 l=1.24
xc_7_9 TOP B0 sky130_fd_pr__cap_mim_m3_1 w=1.24 l=1.24
xc_8_9 TOP B0 sky130_fd_pr__cap_mim_m3_1 w=1.24 l=1.24
xc_9_9 TOP B1 sky130_fd_pr__cap_mim_m3_1 w=1.24 l=1.24
xc_10_9 TOP B1 sky130_fd_pr__cap_mim_m3_1 w=1.24 l=1.24
xc_11_9 TOP B1 sky130_fd_pr__cap_mim_m3_1 w=1.24 l=1.24
xc_12_9 TOP B1 sky130_fd_pr__cap_mim_m3_1 w=1.24 l=1.24
xc_13_9 TOP B2 sky130_fd_pr__cap_mim_m3_1 w=1.24 l=1.24
xc_14_9 TOP B2 sky130_fd_pr__cap_mim_m3_1 w=1.24 l=1.24
xc_15_9 TOP B3 sky130_fd_pr__cap_mim_m3_1 w=1.24 l=1.24
xc_16_9 TOP B5 sky130_fd_pr__cap_mim_m3_1 w=1.24 l=1.24
xc_17_9 TOP B5 sky130_fd_pr__cap_mim_m3_1 w=1.24 l=1.24
xc_18_9 TOP B3 sky130_fd_pr__cap_mim_m3_1 w=1.24 l=1.24
xc_19_9 TOP B2 sky130_fd_pr__cap_mim_m3_1 w=1.24 l=1.24
xc_20_9 TOP B2 sky130_fd_pr__cap_mim_m3_1 w=1.24 l=1.24
xc_21_9 TOP B1 sky130_fd_pr__cap_mim_m3_1 w=1.24 l=1.24
xc_22_9 TOP B1 sky130_fd_pr__cap_mim_m3_1 w=1.24 l=1.24
xc_23_9 TOP B1 sky130_fd_pr__cap_mim_m3_1 w=1.24 l=1.24
xc_24_9 TOP B1 sky130_fd_pr__cap_mim_m3_1 w=1.24 l=1.24
xc_25_9 TOP B0 sky130_fd_pr__cap_mim_m3_1 w=1.24 l=1.24
xc_26_9 TOP B0 sky130_fd_pr__cap_mim_m3_1 w=1.24 l=1.24
xc_27_9 TOP B0 sky130_fd_pr__cap_mim_m3_1 w=1.24 l=1.24
xc_28_9 TOP B0 sky130_fd_pr__cap_mim_m3_1 w=1.24 l=1.24
xc_29_9 TOP B0 sky130_fd_pr__cap_mim_m3_1 w=1.24 l=1.24
xc_30_9 TOP B0 sky130_fd_pr__cap_mim_m3_1 w=1.24 l=1.24
xc_31_9 TOP B0 sky130_fd_pr__cap_mim_m3_1 w=1.24 l=1.24
xc_32_9 TOP B0 sky130_fd_pr__cap_mim_m3_1 w=1.24 l=1.24
xc_33_9 VSS VSS sky130_fd_pr__cap_mim_m3_1 w=1.24 l=1.24
xc_0_10 VSS VSS sky130_fd_pr__cap_mim_m3_1 w=1.24 l=1.24
xc_1_10 TOP B0 sky130_fd_pr__cap_mim_m3_1 w=1.24 l=1.24
xc_2_10 TOP B0 sky130_fd_pr__cap_mim_m3_1 w=1.24 l=1.24
xc_3_10 TOP B0 sky130_fd_pr__cap_mim_m3_1 w=1.24 l=1.24
xc_4_10 TOP B0 sky130_fd_pr__cap_mim_m3_1 w=1.24 l=1.24
xc_5_10 TOP B0 sky130_fd_pr__cap_mim_m3_1 w=1.24 l=1.24
xc_6_10 TOP B0 sky130_fd_pr__cap_mim_m3_1 w=1.24 l=1.24
xc_7_10 TOP B0 sky130_fd_pr__cap_mim_m3_1 w=1.24 l=1.24
xc_8_10 TOP B0 sky130_fd_pr__cap_mim_m3_1 w=1.24 l=1.24
xc_9_10 TOP B1 sky130_fd_pr__cap_mim_m3_1 w=1.24 l=1.24
xc_10_10 TOP B1 sky130_fd_pr__cap_mim_m3_1 w=1.24 l=1.24
xc_11_10 TOP B1 sky130_fd_pr__cap_mim_m3_1 w=1.24 l=1.24
xc_12_10 TOP B1 sky130_fd_pr__cap_mim_m3_1 w=1.24 l=1.24
xc_13_10 TOP B2 sky130_fd_pr__cap_mim_m3_1 w=1.24 l=1.24
xc_14_10 TOP B2 sky130_fd_pr__cap_mim_m3_1 w=1.24 l=1.24
xc_15_10 TOP B3 sky130_fd_pr__cap_mim_m3_1 w=1.24 l=1.24
xc_16_10 TOP B5 sky130_fd_pr__cap_mim_m3_1 w=1.24 l=1.24
xc_17_10 TOP B5 sky130_fd_pr__cap_mim_m3_1 w=1.24 l=1.24
xc_18_10 TOP B3 sky130_fd_pr__cap_mim_m3_1 w=1.24 l=1.24
xc_19_10 TOP B2 sky130_fd_pr__cap_mim_m3_1 w=1.24 l=1.24
xc_20_10 TOP B2 sky130_fd_pr__cap_mim_m3_1 w=1.24 l=1.24
xc_21_10 TOP B1 sky130_fd_pr__cap_mim_m3_1 w=1.24 l=1.24
xc_22_10 TOP B1 sky130_fd_pr__cap_mim_m3_1 w=1.24 l=1.24
xc_23_10 TOP B1 sky130_fd_pr__cap_mim_m3_1 w=1.24 l=1.24
xc_24_10 TOP B1 sky130_fd_pr__cap_mim_m3_1 w=1.24 l=1.24
xc_25_10 TOP B0 sky130_fd_pr__cap_mim_m3_1 w=1.24 l=1.24
xc_26_10 TOP B0 sky130_fd_pr__cap_mim_m3_1 w=1.24 l=1.24
xc_27_10 TOP B0 sky130_fd_pr__cap_mim_m3_1 w=1.24 l=1.24
xc_28_10 TOP B0 sky130_fd_pr__cap_mim_m3_1 w=1.24 l=1.24
xc_29_10 TOP B0 sky130_fd_pr__cap_mim_m3_1 w=1.24 l=1.24
xc_30_10 TOP B0 sky130_fd_pr__cap_mim_m3_1 w=1.24 l=1.24
xc_31_10 TOP B0 sky130_fd_pr__cap_mim_m3_1 w=1.24 l=1.24
xc_32_10 TOP B0 sky130_fd_pr__cap_mim_m3_1 w=1.24 l=1.24
xc_33_10 VSS VSS sky130_fd_pr__cap_mim_m3_1 w=1.24 l=1.24
xc_0_11 VSS VSS sky130_fd_pr__cap_mim_m3_1 w=1.24 l=1.24
xc_1_11 TOP B0 sky130_fd_pr__cap_mim_m3_1 w=1.24 l=1.24
xc_2_11 TOP B0 sky130_fd_pr__cap_mim_m3_1 w=1.24 l=1.24
xc_3_11 TOP B0 sky130_fd_pr__cap_mim_m3_1 w=1.24 l=1.24
xc_4_11 TOP B0 sky130_fd_pr__cap_mim_m3_1 w=1.24 l=1.24
xc_5_11 TOP B0 sky130_fd_pr__cap_mim_m3_1 w=1.24 l=1.24
xc_6_11 TOP B0 sky130_fd_pr__cap_mim_m3_1 w=1.24 l=1.24
xc_7_11 TOP B0 sky130_fd_pr__cap_mim_m3_1 w=1.24 l=1.24
xc_8_11 TOP B0 sky130_fd_pr__cap_mim_m3_1 w=1.24 l=1.24
xc_9_11 TOP B1 sky130_fd_pr__cap_mim_m3_1 w=1.24 l=1.24
xc_10_11 TOP B1 sky130_fd_pr__cap_mim_m3_1 w=1.24 l=1.24
xc_11_11 TOP B1 sky130_fd_pr__cap_mim_m3_1 w=1.24 l=1.24
xc_12_11 TOP B1 sky130_fd_pr__cap_mim_m3_1 w=1.24 l=1.24
xc_13_11 TOP B2 sky130_fd_pr__cap_mim_m3_1 w=1.24 l=1.24
xc_14_11 TOP B2 sky130_fd_pr__cap_mim_m3_1 w=1.24 l=1.24
xc_15_11 TOP B3 sky130_fd_pr__cap_mim_m3_1 w=1.24 l=1.24
xc_16_11 TOP B5 sky130_fd_pr__cap_mim_m3_1 w=1.24 l=1.24
xc_17_11 TOP B5 sky130_fd_pr__cap_mim_m3_1 w=1.24 l=1.24
xc_18_11 TOP B3 sky130_fd_pr__cap_mim_m3_1 w=1.24 l=1.24
xc_19_11 TOP B2 sky130_fd_pr__cap_mim_m3_1 w=1.24 l=1.24
xc_20_11 TOP B2 sky130_fd_pr__cap_mim_m3_1 w=1.24 l=1.24
xc_21_11 TOP B1 sky130_fd_pr__cap_mim_m3_1 w=1.24 l=1.24
xc_22_11 TOP B1 sky130_fd_pr__cap_mim_m3_1 w=1.24 l=1.24
xc_23_11 TOP B1 sky130_fd_pr__cap_mim_m3_1 w=1.24 l=1.24
xc_24_11 TOP B1 sky130_fd_pr__cap_mim_m3_1 w=1.24 l=1.24
xc_25_11 TOP B0 sky130_fd_pr__cap_mim_m3_1 w=1.24 l=1.24
xc_26_11 TOP B0 sky130_fd_pr__cap_mim_m3_1 w=1.24 l=1.24
xc_27_11 TOP B0 sky130_fd_pr__cap_mim_m3_1 w=1.24 l=1.24
xc_28_11 TOP B0 sky130_fd_pr__cap_mim_m3_1 w=1.24 l=1.24
xc_29_11 TOP B0 sky130_fd_pr__cap_mim_m3_1 w=1.24 l=1.24
xc_30_11 TOP B0 sky130_fd_pr__cap_mim_m3_1 w=1.24 l=1.24
xc_31_11 TOP B0 sky130_fd_pr__cap_mim_m3_1 w=1.24 l=1.24
xc_32_11 TOP B0 sky130_fd_pr__cap_mim_m3_1 w=1.24 l=1.24
xc_33_11 VSS VSS sky130_fd_pr__cap_mim_m3_1 w=1.24 l=1.24
xc_0_12 VSS VSS sky130_fd_pr__cap_mim_m3_1 w=1.24 l=1.24
xc_1_12 TOP B0 sky130_fd_pr__cap_mim_m3_1 w=1.24 l=1.24
xc_2_12 TOP B0 sky130_fd_pr__cap_mim_m3_1 w=1.24 l=1.24
xc_3_12 TOP B0 sky130_fd_pr__cap_mim_m3_1 w=1.24 l=1.24
xc_4_12 TOP B0 sky130_fd_pr__cap_mim_m3_1 w=1.24 l=1.24
xc_5_12 TOP B0 sky130_fd_pr__cap_mim_m3_1 w=1.24 l=1.24
xc_6_12 TOP B0 sky130_fd_pr__cap_mim_m3_1 w=1.24 l=1.24
xc_7_12 TOP B0 sky130_fd_pr__cap_mim_m3_1 w=1.24 l=1.24
xc_8_12 TOP B0 sky130_fd_pr__cap_mim_m3_1 w=1.24 l=1.24
xc_9_12 TOP B1 sky130_fd_pr__cap_mim_m3_1 w=1.24 l=1.24
xc_10_12 TOP B1 sky130_fd_pr__cap_mim_m3_1 w=1.24 l=1.24
xc_11_12 TOP B1 sky130_fd_pr__cap_mim_m3_1 w=1.24 l=1.24
xc_12_12 TOP B1 sky130_fd_pr__cap_mim_m3_1 w=1.24 l=1.24
xc_13_12 TOP B2 sky130_fd_pr__cap_mim_m3_1 w=1.24 l=1.24
xc_14_12 TOP B2 sky130_fd_pr__cap_mim_m3_1 w=1.24 l=1.24
xc_15_12 TOP B3 sky130_fd_pr__cap_mim_m3_1 w=1.24 l=1.24
xc_16_12 TOP B5 sky130_fd_pr__cap_mim_m3_1 w=1.24 l=1.24
xc_17_12 TOP B5 sky130_fd_pr__cap_mim_m3_1 w=1.24 l=1.24
xc_18_12 TOP B3 sky130_fd_pr__cap_mim_m3_1 w=1.24 l=1.24
xc_19_12 TOP B2 sky130_fd_pr__cap_mim_m3_1 w=1.24 l=1.24
xc_20_12 TOP B2 sky130_fd_pr__cap_mim_m3_1 w=1.24 l=1.24
xc_21_12 TOP B1 sky130_fd_pr__cap_mim_m3_1 w=1.24 l=1.24
xc_22_12 TOP B1 sky130_fd_pr__cap_mim_m3_1 w=1.24 l=1.24
xc_23_12 TOP B1 sky130_fd_pr__cap_mim_m3_1 w=1.24 l=1.24
xc_24_12 TOP B1 sky130_fd_pr__cap_mim_m3_1 w=1.24 l=1.24
xc_25_12 TOP B0 sky130_fd_pr__cap_mim_m3_1 w=1.24 l=1.24
xc_26_12 TOP B0 sky130_fd_pr__cap_mim_m3_1 w=1.24 l=1.24
xc_27_12 TOP B0 sky130_fd_pr__cap_mim_m3_1 w=1.24 l=1.24
xc_28_12 TOP B0 sky130_fd_pr__cap_mim_m3_1 w=1.24 l=1.24
xc_29_12 TOP B0 sky130_fd_pr__cap_mim_m3_1 w=1.24 l=1.24
xc_30_12 TOP B0 sky130_fd_pr__cap_mim_m3_1 w=1.24 l=1.24
xc_31_12 TOP B0 sky130_fd_pr__cap_mim_m3_1 w=1.24 l=1.24
xc_32_12 TOP B0 sky130_fd_pr__cap_mim_m3_1 w=1.24 l=1.24
xc_33_12 VSS VSS sky130_fd_pr__cap_mim_m3_1 w=1.24 l=1.24
xc_0_13 VSS VSS sky130_fd_pr__cap_mim_m3_1 w=1.24 l=1.24
xc_1_13 TOP B0 sky130_fd_pr__cap_mim_m3_1 w=1.24 l=1.24
xc_2_13 TOP B0 sky130_fd_pr__cap_mim_m3_1 w=1.24 l=1.24
xc_3_13 TOP B0 sky130_fd_pr__cap_mim_m3_1 w=1.24 l=1.24
xc_4_13 TOP B0 sky130_fd_pr__cap_mim_m3_1 w=1.24 l=1.24
xc_5_13 TOP B0 sky130_fd_pr__cap_mim_m3_1 w=1.24 l=1.24
xc_6_13 TOP B0 sky130_fd_pr__cap_mim_m3_1 w=1.24 l=1.24
xc_7_13 TOP B0 sky130_fd_pr__cap_mim_m3_1 w=1.24 l=1.24
xc_8_13 TOP B0 sky130_fd_pr__cap_mim_m3_1 w=1.24 l=1.24
xc_9_13 TOP B1 sky130_fd_pr__cap_mim_m3_1 w=1.24 l=1.24
xc_10_13 TOP B1 sky130_fd_pr__cap_mim_m3_1 w=1.24 l=1.24
xc_11_13 TOP B1 sky130_fd_pr__cap_mim_m3_1 w=1.24 l=1.24
xc_12_13 TOP B1 sky130_fd_pr__cap_mim_m3_1 w=1.24 l=1.24
xc_13_13 TOP B2 sky130_fd_pr__cap_mim_m3_1 w=1.24 l=1.24
xc_14_13 TOP B2 sky130_fd_pr__cap_mim_m3_1 w=1.24 l=1.24
xc_15_13 TOP B3 sky130_fd_pr__cap_mim_m3_1 w=1.24 l=1.24
xc_16_13 TOP B6 sky130_fd_pr__cap_mim_m3_1 w=1.24 l=1.24
xc_17_13 TOP B6 sky130_fd_pr__cap_mim_m3_1 w=1.24 l=1.24
xc_18_13 TOP B3 sky130_fd_pr__cap_mim_m3_1 w=1.24 l=1.24
xc_19_13 TOP B2 sky130_fd_pr__cap_mim_m3_1 w=1.24 l=1.24
xc_20_13 TOP B2 sky130_fd_pr__cap_mim_m3_1 w=1.24 l=1.24
xc_21_13 TOP B1 sky130_fd_pr__cap_mim_m3_1 w=1.24 l=1.24
xc_22_13 TOP B1 sky130_fd_pr__cap_mim_m3_1 w=1.24 l=1.24
xc_23_13 TOP B1 sky130_fd_pr__cap_mim_m3_1 w=1.24 l=1.24
xc_24_13 TOP B1 sky130_fd_pr__cap_mim_m3_1 w=1.24 l=1.24
xc_25_13 TOP B0 sky130_fd_pr__cap_mim_m3_1 w=1.24 l=1.24
xc_26_13 TOP B0 sky130_fd_pr__cap_mim_m3_1 w=1.24 l=1.24
xc_27_13 TOP B0 sky130_fd_pr__cap_mim_m3_1 w=1.24 l=1.24
xc_28_13 TOP B0 sky130_fd_pr__cap_mim_m3_1 w=1.24 l=1.24
xc_29_13 TOP B0 sky130_fd_pr__cap_mim_m3_1 w=1.24 l=1.24
xc_30_13 TOP B0 sky130_fd_pr__cap_mim_m3_1 w=1.24 l=1.24
xc_31_13 TOP B0 sky130_fd_pr__cap_mim_m3_1 w=1.24 l=1.24
xc_32_13 TOP B0 sky130_fd_pr__cap_mim_m3_1 w=1.24 l=1.24
xc_33_13 VSS VSS sky130_fd_pr__cap_mim_m3_1 w=1.24 l=1.24
xc_0_14 VSS VSS sky130_fd_pr__cap_mim_m3_1 w=1.24 l=1.24
xc_1_14 TOP B0 sky130_fd_pr__cap_mim_m3_1 w=1.24 l=1.24
xc_2_14 TOP B0 sky130_fd_pr__cap_mim_m3_1 w=1.24 l=1.24
xc_3_14 TOP B0 sky130_fd_pr__cap_mim_m3_1 w=1.24 l=1.24
xc_4_14 TOP B0 sky130_fd_pr__cap_mim_m3_1 w=1.24 l=1.24
xc_5_14 TOP B0 sky130_fd_pr__cap_mim_m3_1 w=1.24 l=1.24
xc_6_14 TOP B0 sky130_fd_pr__cap_mim_m3_1 w=1.24 l=1.24
xc_7_14 TOP B0 sky130_fd_pr__cap_mim_m3_1 w=1.24 l=1.24
xc_8_14 TOP B0 sky130_fd_pr__cap_mim_m3_1 w=1.24 l=1.24
xc_9_14 TOP B1 sky130_fd_pr__cap_mim_m3_1 w=1.24 l=1.24
xc_10_14 TOP B1 sky130_fd_pr__cap_mim_m3_1 w=1.24 l=1.24
xc_11_14 TOP B1 sky130_fd_pr__cap_mim_m3_1 w=1.24 l=1.24
xc_12_14 TOP B1 sky130_fd_pr__cap_mim_m3_1 w=1.24 l=1.24
xc_13_14 TOP B2 sky130_fd_pr__cap_mim_m3_1 w=1.24 l=1.24
xc_14_14 TOP B2 sky130_fd_pr__cap_mim_m3_1 w=1.24 l=1.24
xc_15_14 TOP B3 sky130_fd_pr__cap_mim_m3_1 w=1.24 l=1.24
xc_16_14 TOP B6 sky130_fd_pr__cap_mim_m3_1 w=1.24 l=1.24
xc_17_14 TOP B6 sky130_fd_pr__cap_mim_m3_1 w=1.24 l=1.24
xc_18_14 TOP B3 sky130_fd_pr__cap_mim_m3_1 w=1.24 l=1.24
xc_19_14 TOP B2 sky130_fd_pr__cap_mim_m3_1 w=1.24 l=1.24
xc_20_14 TOP B2 sky130_fd_pr__cap_mim_m3_1 w=1.24 l=1.24
xc_21_14 TOP B1 sky130_fd_pr__cap_mim_m3_1 w=1.24 l=1.24
xc_22_14 TOP B1 sky130_fd_pr__cap_mim_m3_1 w=1.24 l=1.24
xc_23_14 TOP B1 sky130_fd_pr__cap_mim_m3_1 w=1.24 l=1.24
xc_24_14 TOP B1 sky130_fd_pr__cap_mim_m3_1 w=1.24 l=1.24
xc_25_14 TOP B0 sky130_fd_pr__cap_mim_m3_1 w=1.24 l=1.24
xc_26_14 TOP B0 sky130_fd_pr__cap_mim_m3_1 w=1.24 l=1.24
xc_27_14 TOP B0 sky130_fd_pr__cap_mim_m3_1 w=1.24 l=1.24
xc_28_14 TOP B0 sky130_fd_pr__cap_mim_m3_1 w=1.24 l=1.24
xc_29_14 TOP B0 sky130_fd_pr__cap_mim_m3_1 w=1.24 l=1.24
xc_30_14 TOP B0 sky130_fd_pr__cap_mim_m3_1 w=1.24 l=1.24
xc_31_14 TOP B0 sky130_fd_pr__cap_mim_m3_1 w=1.24 l=1.24
xc_32_14 TOP B0 sky130_fd_pr__cap_mim_m3_1 w=1.24 l=1.24
xc_33_14 VSS VSS sky130_fd_pr__cap_mim_m3_1 w=1.24 l=1.24
xc_0_15 VSS VSS sky130_fd_pr__cap_mim_m3_1 w=1.24 l=1.24
xc_1_15 TOP B0 sky130_fd_pr__cap_mim_m3_1 w=1.24 l=1.24
xc_2_15 TOP B0 sky130_fd_pr__cap_mim_m3_1 w=1.24 l=1.24
xc_3_15 TOP B0 sky130_fd_pr__cap_mim_m3_1 w=1.24 l=1.24
xc_4_15 TOP B0 sky130_fd_pr__cap_mim_m3_1 w=1.24 l=1.24
xc_5_15 TOP B0 sky130_fd_pr__cap_mim_m3_1 w=1.24 l=1.24
xc_6_15 TOP B0 sky130_fd_pr__cap_mim_m3_1 w=1.24 l=1.24
xc_7_15 TOP B0 sky130_fd_pr__cap_mim_m3_1 w=1.24 l=1.24
xc_8_15 TOP B0 sky130_fd_pr__cap_mim_m3_1 w=1.24 l=1.24
xc_9_15 TOP B1 sky130_fd_pr__cap_mim_m3_1 w=1.24 l=1.24
xc_10_15 TOP B1 sky130_fd_pr__cap_mim_m3_1 w=1.24 l=1.24
xc_11_15 TOP B1 sky130_fd_pr__cap_mim_m3_1 w=1.24 l=1.24
xc_12_15 TOP B1 sky130_fd_pr__cap_mim_m3_1 w=1.24 l=1.24
xc_13_15 TOP B2 sky130_fd_pr__cap_mim_m3_1 w=1.24 l=1.24
xc_14_15 TOP B2 sky130_fd_pr__cap_mim_m3_1 w=1.24 l=1.24
xc_15_15 TOP B3 sky130_fd_pr__cap_mim_m3_1 w=1.24 l=1.24
xc_16_15 TOP B7 sky130_fd_pr__cap_mim_m3_1 w=1.24 l=1.24
xc_17_15 TOP B7 sky130_fd_pr__cap_mim_m3_1 w=1.24 l=1.24
xc_18_15 TOP B3 sky130_fd_pr__cap_mim_m3_1 w=1.24 l=1.24
xc_19_15 TOP B2 sky130_fd_pr__cap_mim_m3_1 w=1.24 l=1.24
xc_20_15 TOP B2 sky130_fd_pr__cap_mim_m3_1 w=1.24 l=1.24
xc_21_15 TOP B1 sky130_fd_pr__cap_mim_m3_1 w=1.24 l=1.24
xc_22_15 TOP B1 sky130_fd_pr__cap_mim_m3_1 w=1.24 l=1.24
xc_23_15 TOP B1 sky130_fd_pr__cap_mim_m3_1 w=1.24 l=1.24
xc_24_15 TOP B1 sky130_fd_pr__cap_mim_m3_1 w=1.24 l=1.24
xc_25_15 TOP B0 sky130_fd_pr__cap_mim_m3_1 w=1.24 l=1.24
xc_26_15 TOP B0 sky130_fd_pr__cap_mim_m3_1 w=1.24 l=1.24
xc_27_15 TOP B0 sky130_fd_pr__cap_mim_m3_1 w=1.24 l=1.24
xc_28_15 TOP B0 sky130_fd_pr__cap_mim_m3_1 w=1.24 l=1.24
xc_29_15 TOP B0 sky130_fd_pr__cap_mim_m3_1 w=1.24 l=1.24
xc_30_15 TOP B0 sky130_fd_pr__cap_mim_m3_1 w=1.24 l=1.24
xc_31_15 TOP B0 sky130_fd_pr__cap_mim_m3_1 w=1.24 l=1.24
xc_32_15 TOP B0 sky130_fd_pr__cap_mim_m3_1 w=1.24 l=1.24
xc_33_15 VSS VSS sky130_fd_pr__cap_mim_m3_1 w=1.24 l=1.24
xc_0_16 VSS VSS sky130_fd_pr__cap_mim_m3_1 w=1.24 l=1.24
xc_1_16 TOP B0 sky130_fd_pr__cap_mim_m3_1 w=1.24 l=1.24
xc_2_16 TOP B0 sky130_fd_pr__cap_mim_m3_1 w=1.24 l=1.24
xc_3_16 TOP B0 sky130_fd_pr__cap_mim_m3_1 w=1.24 l=1.24
xc_4_16 TOP B0 sky130_fd_pr__cap_mim_m3_1 w=1.24 l=1.24
xc_5_16 TOP B0 sky130_fd_pr__cap_mim_m3_1 w=1.24 l=1.24
xc_6_16 TOP B0 sky130_fd_pr__cap_mim_m3_1 w=1.24 l=1.24
xc_7_16 TOP B0 sky130_fd_pr__cap_mim_m3_1 w=1.24 l=1.24
xc_8_16 TOP B0 sky130_fd_pr__cap_mim_m3_1 w=1.24 l=1.24
xc_9_16 TOP B1 sky130_fd_pr__cap_mim_m3_1 w=1.24 l=1.24
xc_10_16 TOP B1 sky130_fd_pr__cap_mim_m3_1 w=1.24 l=1.24
xc_11_16 TOP B1 sky130_fd_pr__cap_mim_m3_1 w=1.24 l=1.24
xc_12_16 TOP B1 sky130_fd_pr__cap_mim_m3_1 w=1.24 l=1.24
xc_13_16 TOP B2 sky130_fd_pr__cap_mim_m3_1 w=1.24 l=1.24
xc_14_16 TOP B2 sky130_fd_pr__cap_mim_m3_1 w=1.24 l=1.24
xc_15_16 TOP B3 sky130_fd_pr__cap_mim_m3_1 w=1.24 l=1.24
xc_16_16 TOP B8 sky130_fd_pr__cap_mim_m3_1 w=1.24 l=1.24
xc_17_16 TOP B9 sky130_fd_pr__cap_mim_m3_1 w=1.24 l=1.24
xc_18_16 TOP B3 sky130_fd_pr__cap_mim_m3_1 w=1.24 l=1.24
xc_19_16 TOP B2 sky130_fd_pr__cap_mim_m3_1 w=1.24 l=1.24
xc_20_16 TOP B2 sky130_fd_pr__cap_mim_m3_1 w=1.24 l=1.24
xc_21_16 TOP B1 sky130_fd_pr__cap_mim_m3_1 w=1.24 l=1.24
xc_22_16 TOP B1 sky130_fd_pr__cap_mim_m3_1 w=1.24 l=1.24
xc_23_16 TOP B1 sky130_fd_pr__cap_mim_m3_1 w=1.24 l=1.24
xc_24_16 TOP B1 sky130_fd_pr__cap_mim_m3_1 w=1.24 l=1.24
xc_25_16 TOP B0 sky130_fd_pr__cap_mim_m3_1 w=1.24 l=1.24
xc_26_16 TOP B0 sky130_fd_pr__cap_mim_m3_1 w=1.24 l=1.24
xc_27_16 TOP B0 sky130_fd_pr__cap_mim_m3_1 w=1.24 l=1.24
xc_28_16 TOP B0 sky130_fd_pr__cap_mim_m3_1 w=1.24 l=1.24
xc_29_16 TOP B0 sky130_fd_pr__cap_mim_m3_1 w=1.24 l=1.24
xc_30_16 TOP B0 sky130_fd_pr__cap_mim_m3_1 w=1.24 l=1.24
xc_31_16 TOP B0 sky130_fd_pr__cap_mim_m3_1 w=1.24 l=1.24
xc_32_16 TOP B0 sky130_fd_pr__cap_mim_m3_1 w=1.24 l=1.24
xc_33_16 VSS VSS sky130_fd_pr__cap_mim_m3_1 w=1.24 l=1.24
xc_0_17 VSS VSS sky130_fd_pr__cap_mim_m3_1 w=1.24 l=1.24
xc_1_17 TOP B0 sky130_fd_pr__cap_mim_m3_1 w=1.24 l=1.24
xc_2_17 TOP B0 sky130_fd_pr__cap_mim_m3_1 w=1.24 l=1.24
xc_3_17 TOP B0 sky130_fd_pr__cap_mim_m3_1 w=1.24 l=1.24
xc_4_17 TOP B0 sky130_fd_pr__cap_mim_m3_1 w=1.24 l=1.24
xc_5_17 TOP B0 sky130_fd_pr__cap_mim_m3_1 w=1.24 l=1.24
xc_6_17 TOP B0 sky130_fd_pr__cap_mim_m3_1 w=1.24 l=1.24
xc_7_17 TOP B0 sky130_fd_pr__cap_mim_m3_1 w=1.24 l=1.24
xc_8_17 TOP B0 sky130_fd_pr__cap_mim_m3_1 w=1.24 l=1.24
xc_9_17 TOP B1 sky130_fd_pr__cap_mim_m3_1 w=1.24 l=1.24
xc_10_17 TOP B1 sky130_fd_pr__cap_mim_m3_1 w=1.24 l=1.24
xc_11_17 TOP B1 sky130_fd_pr__cap_mim_m3_1 w=1.24 l=1.24
xc_12_17 TOP B1 sky130_fd_pr__cap_mim_m3_1 w=1.24 l=1.24
xc_13_17 TOP B2 sky130_fd_pr__cap_mim_m3_1 w=1.24 l=1.24
xc_14_17 TOP B2 sky130_fd_pr__cap_mim_m3_1 w=1.24 l=1.24
xc_15_17 TOP B3 sky130_fd_pr__cap_mim_m3_1 w=1.24 l=1.24
xc_16_17 TOP B10 sky130_fd_pr__cap_mim_m3_1 w=1.24 l=1.24
xc_17_17 TOP B8 sky130_fd_pr__cap_mim_m3_1 w=1.24 l=1.24
xc_18_17 TOP B3 sky130_fd_pr__cap_mim_m3_1 w=1.24 l=1.24
xc_19_17 TOP B2 sky130_fd_pr__cap_mim_m3_1 w=1.24 l=1.24
xc_20_17 TOP B2 sky130_fd_pr__cap_mim_m3_1 w=1.24 l=1.24
xc_21_17 TOP B1 sky130_fd_pr__cap_mim_m3_1 w=1.24 l=1.24
xc_22_17 TOP B1 sky130_fd_pr__cap_mim_m3_1 w=1.24 l=1.24
xc_23_17 TOP B1 sky130_fd_pr__cap_mim_m3_1 w=1.24 l=1.24
xc_24_17 TOP B1 sky130_fd_pr__cap_mim_m3_1 w=1.24 l=1.24
xc_25_17 TOP B0 sky130_fd_pr__cap_mim_m3_1 w=1.24 l=1.24
xc_26_17 TOP B0 sky130_fd_pr__cap_mim_m3_1 w=1.24 l=1.24
xc_27_17 TOP B0 sky130_fd_pr__cap_mim_m3_1 w=1.24 l=1.24
xc_28_17 TOP B0 sky130_fd_pr__cap_mim_m3_1 w=1.24 l=1.24
xc_29_17 TOP B0 sky130_fd_pr__cap_mim_m3_1 w=1.24 l=1.24
xc_30_17 TOP B0 sky130_fd_pr__cap_mim_m3_1 w=1.24 l=1.24
xc_31_17 TOP B0 sky130_fd_pr__cap_mim_m3_1 w=1.24 l=1.24
xc_32_17 TOP B0 sky130_fd_pr__cap_mim_m3_1 w=1.24 l=1.24
xc_33_17 VSS VSS sky130_fd_pr__cap_mim_m3_1 w=1.24 l=1.24
xc_0_18 VSS VSS sky130_fd_pr__cap_mim_m3_1 w=1.24 l=1.24
xc_1_18 TOP B0 sky130_fd_pr__cap_mim_m3_1 w=1.24 l=1.24
xc_2_18 TOP B0 sky130_fd_pr__cap_mim_m3_1 w=1.24 l=1.24
xc_3_18 TOP B0 sky130_fd_pr__cap_mim_m3_1 w=1.24 l=1.24
xc_4_18 TOP B0 sky130_fd_pr__cap_mim_m3_1 w=1.24 l=1.24
xc_5_18 TOP B0 sky130_fd_pr__cap_mim_m3_1 w=1.24 l=1.24
xc_6_18 TOP B0 sky130_fd_pr__cap_mim_m3_1 w=1.24 l=1.24
xc_7_18 TOP B0 sky130_fd_pr__cap_mim_m3_1 w=1.24 l=1.24
xc_8_18 TOP B0 sky130_fd_pr__cap_mim_m3_1 w=1.24 l=1.24
xc_9_18 TOP B1 sky130_fd_pr__cap_mim_m3_1 w=1.24 l=1.24
xc_10_18 TOP B1 sky130_fd_pr__cap_mim_m3_1 w=1.24 l=1.24
xc_11_18 TOP B1 sky130_fd_pr__cap_mim_m3_1 w=1.24 l=1.24
xc_12_18 TOP B1 sky130_fd_pr__cap_mim_m3_1 w=1.24 l=1.24
xc_13_18 TOP B2 sky130_fd_pr__cap_mim_m3_1 w=1.24 l=1.24
xc_14_18 TOP B2 sky130_fd_pr__cap_mim_m3_1 w=1.24 l=1.24
xc_15_18 TOP B3 sky130_fd_pr__cap_mim_m3_1 w=1.24 l=1.24
xc_16_18 TOP B7 sky130_fd_pr__cap_mim_m3_1 w=1.24 l=1.24
xc_17_18 TOP B7 sky130_fd_pr__cap_mim_m3_1 w=1.24 l=1.24
xc_18_18 TOP B3 sky130_fd_pr__cap_mim_m3_1 w=1.24 l=1.24
xc_19_18 TOP B2 sky130_fd_pr__cap_mim_m3_1 w=1.24 l=1.24
xc_20_18 TOP B2 sky130_fd_pr__cap_mim_m3_1 w=1.24 l=1.24
xc_21_18 TOP B1 sky130_fd_pr__cap_mim_m3_1 w=1.24 l=1.24
xc_22_18 TOP B1 sky130_fd_pr__cap_mim_m3_1 w=1.24 l=1.24
xc_23_18 TOP B1 sky130_fd_pr__cap_mim_m3_1 w=1.24 l=1.24
xc_24_18 TOP B1 sky130_fd_pr__cap_mim_m3_1 w=1.24 l=1.24
xc_25_18 TOP B0 sky130_fd_pr__cap_mim_m3_1 w=1.24 l=1.24
xc_26_18 TOP B0 sky130_fd_pr__cap_mim_m3_1 w=1.24 l=1.24
xc_27_18 TOP B0 sky130_fd_pr__cap_mim_m3_1 w=1.24 l=1.24
xc_28_18 TOP B0 sky130_fd_pr__cap_mim_m3_1 w=1.24 l=1.24
xc_29_18 TOP B0 sky130_fd_pr__cap_mim_m3_1 w=1.24 l=1.24
xc_30_18 TOP B0 sky130_fd_pr__cap_mim_m3_1 w=1.24 l=1.24
xc_31_18 TOP B0 sky130_fd_pr__cap_mim_m3_1 w=1.24 l=1.24
xc_32_18 TOP B0 sky130_fd_pr__cap_mim_m3_1 w=1.24 l=1.24
xc_33_18 VSS VSS sky130_fd_pr__cap_mim_m3_1 w=1.24 l=1.24
xc_0_19 VSS VSS sky130_fd_pr__cap_mim_m3_1 w=1.24 l=1.24
xc_1_19 TOP B0 sky130_fd_pr__cap_mim_m3_1 w=1.24 l=1.24
xc_2_19 TOP B0 sky130_fd_pr__cap_mim_m3_1 w=1.24 l=1.24
xc_3_19 TOP B0 sky130_fd_pr__cap_mim_m3_1 w=1.24 l=1.24
xc_4_19 TOP B0 sky130_fd_pr__cap_mim_m3_1 w=1.24 l=1.24
xc_5_19 TOP B0 sky130_fd_pr__cap_mim_m3_1 w=1.24 l=1.24
xc_6_19 TOP B0 sky130_fd_pr__cap_mim_m3_1 w=1.24 l=1.24
xc_7_19 TOP B0 sky130_fd_pr__cap_mim_m3_1 w=1.24 l=1.24
xc_8_19 TOP B0 sky130_fd_pr__cap_mim_m3_1 w=1.24 l=1.24
xc_9_19 TOP B1 sky130_fd_pr__cap_mim_m3_1 w=1.24 l=1.24
xc_10_19 TOP B1 sky130_fd_pr__cap_mim_m3_1 w=1.24 l=1.24
xc_11_19 TOP B1 sky130_fd_pr__cap_mim_m3_1 w=1.24 l=1.24
xc_12_19 TOP B1 sky130_fd_pr__cap_mim_m3_1 w=1.24 l=1.24
xc_13_19 TOP B2 sky130_fd_pr__cap_mim_m3_1 w=1.24 l=1.24
xc_14_19 TOP B2 sky130_fd_pr__cap_mim_m3_1 w=1.24 l=1.24
xc_15_19 TOP B3 sky130_fd_pr__cap_mim_m3_1 w=1.24 l=1.24
xc_16_19 TOP B6 sky130_fd_pr__cap_mim_m3_1 w=1.24 l=1.24
xc_17_19 TOP B6 sky130_fd_pr__cap_mim_m3_1 w=1.24 l=1.24
xc_18_19 TOP B3 sky130_fd_pr__cap_mim_m3_1 w=1.24 l=1.24
xc_19_19 TOP B2 sky130_fd_pr__cap_mim_m3_1 w=1.24 l=1.24
xc_20_19 TOP B2 sky130_fd_pr__cap_mim_m3_1 w=1.24 l=1.24
xc_21_19 TOP B1 sky130_fd_pr__cap_mim_m3_1 w=1.24 l=1.24
xc_22_19 TOP B1 sky130_fd_pr__cap_mim_m3_1 w=1.24 l=1.24
xc_23_19 TOP B1 sky130_fd_pr__cap_mim_m3_1 w=1.24 l=1.24
xc_24_19 TOP B1 sky130_fd_pr__cap_mim_m3_1 w=1.24 l=1.24
xc_25_19 TOP B0 sky130_fd_pr__cap_mim_m3_1 w=1.24 l=1.24
xc_26_19 TOP B0 sky130_fd_pr__cap_mim_m3_1 w=1.24 l=1.24
xc_27_19 TOP B0 sky130_fd_pr__cap_mim_m3_1 w=1.24 l=1.24
xc_28_19 TOP B0 sky130_fd_pr__cap_mim_m3_1 w=1.24 l=1.24
xc_29_19 TOP B0 sky130_fd_pr__cap_mim_m3_1 w=1.24 l=1.24
xc_30_19 TOP B0 sky130_fd_pr__cap_mim_m3_1 w=1.24 l=1.24
xc_31_19 TOP B0 sky130_fd_pr__cap_mim_m3_1 w=1.24 l=1.24
xc_32_19 TOP B0 sky130_fd_pr__cap_mim_m3_1 w=1.24 l=1.24
xc_33_19 VSS VSS sky130_fd_pr__cap_mim_m3_1 w=1.24 l=1.24
xc_0_20 VSS VSS sky130_fd_pr__cap_mim_m3_1 w=1.24 l=1.24
xc_1_20 TOP B0 sky130_fd_pr__cap_mim_m3_1 w=1.24 l=1.24
xc_2_20 TOP B0 sky130_fd_pr__cap_mim_m3_1 w=1.24 l=1.24
xc_3_20 TOP B0 sky130_fd_pr__cap_mim_m3_1 w=1.24 l=1.24
xc_4_20 TOP B0 sky130_fd_pr__cap_mim_m3_1 w=1.24 l=1.24
xc_5_20 TOP B0 sky130_fd_pr__cap_mim_m3_1 w=1.24 l=1.24
xc_6_20 TOP B0 sky130_fd_pr__cap_mim_m3_1 w=1.24 l=1.24
xc_7_20 TOP B0 sky130_fd_pr__cap_mim_m3_1 w=1.24 l=1.24
xc_8_20 TOP B0 sky130_fd_pr__cap_mim_m3_1 w=1.24 l=1.24
xc_9_20 TOP B1 sky130_fd_pr__cap_mim_m3_1 w=1.24 l=1.24
xc_10_20 TOP B1 sky130_fd_pr__cap_mim_m3_1 w=1.24 l=1.24
xc_11_20 TOP B1 sky130_fd_pr__cap_mim_m3_1 w=1.24 l=1.24
xc_12_20 TOP B1 sky130_fd_pr__cap_mim_m3_1 w=1.24 l=1.24
xc_13_20 TOP B2 sky130_fd_pr__cap_mim_m3_1 w=1.24 l=1.24
xc_14_20 TOP B2 sky130_fd_pr__cap_mim_m3_1 w=1.24 l=1.24
xc_15_20 TOP B3 sky130_fd_pr__cap_mim_m3_1 w=1.24 l=1.24
xc_16_20 TOP B6 sky130_fd_pr__cap_mim_m3_1 w=1.24 l=1.24
xc_17_20 TOP B6 sky130_fd_pr__cap_mim_m3_1 w=1.24 l=1.24
xc_18_20 TOP B3 sky130_fd_pr__cap_mim_m3_1 w=1.24 l=1.24
xc_19_20 TOP B2 sky130_fd_pr__cap_mim_m3_1 w=1.24 l=1.24
xc_20_20 TOP B2 sky130_fd_pr__cap_mim_m3_1 w=1.24 l=1.24
xc_21_20 TOP B1 sky130_fd_pr__cap_mim_m3_1 w=1.24 l=1.24
xc_22_20 TOP B1 sky130_fd_pr__cap_mim_m3_1 w=1.24 l=1.24
xc_23_20 TOP B1 sky130_fd_pr__cap_mim_m3_1 w=1.24 l=1.24
xc_24_20 TOP B1 sky130_fd_pr__cap_mim_m3_1 w=1.24 l=1.24
xc_25_20 TOP B0 sky130_fd_pr__cap_mim_m3_1 w=1.24 l=1.24
xc_26_20 TOP B0 sky130_fd_pr__cap_mim_m3_1 w=1.24 l=1.24
xc_27_20 TOP B0 sky130_fd_pr__cap_mim_m3_1 w=1.24 l=1.24
xc_28_20 TOP B0 sky130_fd_pr__cap_mim_m3_1 w=1.24 l=1.24
xc_29_20 TOP B0 sky130_fd_pr__cap_mim_m3_1 w=1.24 l=1.24
xc_30_20 TOP B0 sky130_fd_pr__cap_mim_m3_1 w=1.24 l=1.24
xc_31_20 TOP B0 sky130_fd_pr__cap_mim_m3_1 w=1.24 l=1.24
xc_32_20 TOP B0 sky130_fd_pr__cap_mim_m3_1 w=1.24 l=1.24
xc_33_20 VSS VSS sky130_fd_pr__cap_mim_m3_1 w=1.24 l=1.24
xc_0_21 VSS VSS sky130_fd_pr__cap_mim_m3_1 w=1.24 l=1.24
xc_1_21 TOP B0 sky130_fd_pr__cap_mim_m3_1 w=1.24 l=1.24
xc_2_21 TOP B0 sky130_fd_pr__cap_mim_m3_1 w=1.24 l=1.24
xc_3_21 TOP B0 sky130_fd_pr__cap_mim_m3_1 w=1.24 l=1.24
xc_4_21 TOP B0 sky130_fd_pr__cap_mim_m3_1 w=1.24 l=1.24
xc_5_21 TOP B0 sky130_fd_pr__cap_mim_m3_1 w=1.24 l=1.24
xc_6_21 TOP B0 sky130_fd_pr__cap_mim_m3_1 w=1.24 l=1.24
xc_7_21 TOP B0 sky130_fd_pr__cap_mim_m3_1 w=1.24 l=1.24
xc_8_21 TOP B0 sky130_fd_pr__cap_mim_m3_1 w=1.24 l=1.24
xc_9_21 TOP B1 sky130_fd_pr__cap_mim_m3_1 w=1.24 l=1.24
xc_10_21 TOP B1 sky130_fd_pr__cap_mim_m3_1 w=1.24 l=1.24
xc_11_21 TOP B1 sky130_fd_pr__cap_mim_m3_1 w=1.24 l=1.24
xc_12_21 TOP B1 sky130_fd_pr__cap_mim_m3_1 w=1.24 l=1.24
xc_13_21 TOP B2 sky130_fd_pr__cap_mim_m3_1 w=1.24 l=1.24
xc_14_21 TOP B2 sky130_fd_pr__cap_mim_m3_1 w=1.24 l=1.24
xc_15_21 TOP B3 sky130_fd_pr__cap_mim_m3_1 w=1.24 l=1.24
xc_16_21 TOP B5 sky130_fd_pr__cap_mim_m3_1 w=1.24 l=1.24
xc_17_21 TOP B5 sky130_fd_pr__cap_mim_m3_1 w=1.24 l=1.24
xc_18_21 TOP B3 sky130_fd_pr__cap_mim_m3_1 w=1.24 l=1.24
xc_19_21 TOP B2 sky130_fd_pr__cap_mim_m3_1 w=1.24 l=1.24
xc_20_21 TOP B2 sky130_fd_pr__cap_mim_m3_1 w=1.24 l=1.24
xc_21_21 TOP B1 sky130_fd_pr__cap_mim_m3_1 w=1.24 l=1.24
xc_22_21 TOP B1 sky130_fd_pr__cap_mim_m3_1 w=1.24 l=1.24
xc_23_21 TOP B1 sky130_fd_pr__cap_mim_m3_1 w=1.24 l=1.24
xc_24_21 TOP B1 sky130_fd_pr__cap_mim_m3_1 w=1.24 l=1.24
xc_25_21 TOP B0 sky130_fd_pr__cap_mim_m3_1 w=1.24 l=1.24
xc_26_21 TOP B0 sky130_fd_pr__cap_mim_m3_1 w=1.24 l=1.24
xc_27_21 TOP B0 sky130_fd_pr__cap_mim_m3_1 w=1.24 l=1.24
xc_28_21 TOP B0 sky130_fd_pr__cap_mim_m3_1 w=1.24 l=1.24
xc_29_21 TOP B0 sky130_fd_pr__cap_mim_m3_1 w=1.24 l=1.24
xc_30_21 TOP B0 sky130_fd_pr__cap_mim_m3_1 w=1.24 l=1.24
xc_31_21 TOP B0 sky130_fd_pr__cap_mim_m3_1 w=1.24 l=1.24
xc_32_21 TOP B0 sky130_fd_pr__cap_mim_m3_1 w=1.24 l=1.24
xc_33_21 VSS VSS sky130_fd_pr__cap_mim_m3_1 w=1.24 l=1.24
xc_0_22 VSS VSS sky130_fd_pr__cap_mim_m3_1 w=1.24 l=1.24
xc_1_22 TOP B0 sky130_fd_pr__cap_mim_m3_1 w=1.24 l=1.24
xc_2_22 TOP B0 sky130_fd_pr__cap_mim_m3_1 w=1.24 l=1.24
xc_3_22 TOP B0 sky130_fd_pr__cap_mim_m3_1 w=1.24 l=1.24
xc_4_22 TOP B0 sky130_fd_pr__cap_mim_m3_1 w=1.24 l=1.24
xc_5_22 TOP B0 sky130_fd_pr__cap_mim_m3_1 w=1.24 l=1.24
xc_6_22 TOP B0 sky130_fd_pr__cap_mim_m3_1 w=1.24 l=1.24
xc_7_22 TOP B0 sky130_fd_pr__cap_mim_m3_1 w=1.24 l=1.24
xc_8_22 TOP B0 sky130_fd_pr__cap_mim_m3_1 w=1.24 l=1.24
xc_9_22 TOP B1 sky130_fd_pr__cap_mim_m3_1 w=1.24 l=1.24
xc_10_22 TOP B1 sky130_fd_pr__cap_mim_m3_1 w=1.24 l=1.24
xc_11_22 TOP B1 sky130_fd_pr__cap_mim_m3_1 w=1.24 l=1.24
xc_12_22 TOP B1 sky130_fd_pr__cap_mim_m3_1 w=1.24 l=1.24
xc_13_22 TOP B2 sky130_fd_pr__cap_mim_m3_1 w=1.24 l=1.24
xc_14_22 TOP B2 sky130_fd_pr__cap_mim_m3_1 w=1.24 l=1.24
xc_15_22 TOP B3 sky130_fd_pr__cap_mim_m3_1 w=1.24 l=1.24
xc_16_22 TOP B5 sky130_fd_pr__cap_mim_m3_1 w=1.24 l=1.24
xc_17_22 TOP B5 sky130_fd_pr__cap_mim_m3_1 w=1.24 l=1.24
xc_18_22 TOP B3 sky130_fd_pr__cap_mim_m3_1 w=1.24 l=1.24
xc_19_22 TOP B2 sky130_fd_pr__cap_mim_m3_1 w=1.24 l=1.24
xc_20_22 TOP B2 sky130_fd_pr__cap_mim_m3_1 w=1.24 l=1.24
xc_21_22 TOP B1 sky130_fd_pr__cap_mim_m3_1 w=1.24 l=1.24
xc_22_22 TOP B1 sky130_fd_pr__cap_mim_m3_1 w=1.24 l=1.24
xc_23_22 TOP B1 sky130_fd_pr__cap_mim_m3_1 w=1.24 l=1.24
xc_24_22 TOP B1 sky130_fd_pr__cap_mim_m3_1 w=1.24 l=1.24
xc_25_22 TOP B0 sky130_fd_pr__cap_mim_m3_1 w=1.24 l=1.24
xc_26_22 TOP B0 sky130_fd_pr__cap_mim_m3_1 w=1.24 l=1.24
xc_27_22 TOP B0 sky130_fd_pr__cap_mim_m3_1 w=1.24 l=1.24
xc_28_22 TOP B0 sky130_fd_pr__cap_mim_m3_1 w=1.24 l=1.24
xc_29_22 TOP B0 sky130_fd_pr__cap_mim_m3_1 w=1.24 l=1.24
xc_30_22 TOP B0 sky130_fd_pr__cap_mim_m3_1 w=1.24 l=1.24
xc_31_22 TOP B0 sky130_fd_pr__cap_mim_m3_1 w=1.24 l=1.24
xc_32_22 TOP B0 sky130_fd_pr__cap_mim_m3_1 w=1.24 l=1.24
xc_33_22 VSS VSS sky130_fd_pr__cap_mim_m3_1 w=1.24 l=1.24
xc_0_23 VSS VSS sky130_fd_pr__cap_mim_m3_1 w=1.24 l=1.24
xc_1_23 TOP B0 sky130_fd_pr__cap_mim_m3_1 w=1.24 l=1.24
xc_2_23 TOP B0 sky130_fd_pr__cap_mim_m3_1 w=1.24 l=1.24
xc_3_23 TOP B0 sky130_fd_pr__cap_mim_m3_1 w=1.24 l=1.24
xc_4_23 TOP B0 sky130_fd_pr__cap_mim_m3_1 w=1.24 l=1.24
xc_5_23 TOP B0 sky130_fd_pr__cap_mim_m3_1 w=1.24 l=1.24
xc_6_23 TOP B0 sky130_fd_pr__cap_mim_m3_1 w=1.24 l=1.24
xc_7_23 TOP B0 sky130_fd_pr__cap_mim_m3_1 w=1.24 l=1.24
xc_8_23 TOP B0 sky130_fd_pr__cap_mim_m3_1 w=1.24 l=1.24
xc_9_23 TOP B1 sky130_fd_pr__cap_mim_m3_1 w=1.24 l=1.24
xc_10_23 TOP B1 sky130_fd_pr__cap_mim_m3_1 w=1.24 l=1.24
xc_11_23 TOP B1 sky130_fd_pr__cap_mim_m3_1 w=1.24 l=1.24
xc_12_23 TOP B1 sky130_fd_pr__cap_mim_m3_1 w=1.24 l=1.24
xc_13_23 TOP B2 sky130_fd_pr__cap_mim_m3_1 w=1.24 l=1.24
xc_14_23 TOP B2 sky130_fd_pr__cap_mim_m3_1 w=1.24 l=1.24
xc_15_23 TOP B3 sky130_fd_pr__cap_mim_m3_1 w=1.24 l=1.24
xc_16_23 TOP B5 sky130_fd_pr__cap_mim_m3_1 w=1.24 l=1.24
xc_17_23 TOP B5 sky130_fd_pr__cap_mim_m3_1 w=1.24 l=1.24
xc_18_23 TOP B3 sky130_fd_pr__cap_mim_m3_1 w=1.24 l=1.24
xc_19_23 TOP B2 sky130_fd_pr__cap_mim_m3_1 w=1.24 l=1.24
xc_20_23 TOP B2 sky130_fd_pr__cap_mim_m3_1 w=1.24 l=1.24
xc_21_23 TOP B1 sky130_fd_pr__cap_mim_m3_1 w=1.24 l=1.24
xc_22_23 TOP B1 sky130_fd_pr__cap_mim_m3_1 w=1.24 l=1.24
xc_23_23 TOP B1 sky130_fd_pr__cap_mim_m3_1 w=1.24 l=1.24
xc_24_23 TOP B1 sky130_fd_pr__cap_mim_m3_1 w=1.24 l=1.24
xc_25_23 TOP B0 sky130_fd_pr__cap_mim_m3_1 w=1.24 l=1.24
xc_26_23 TOP B0 sky130_fd_pr__cap_mim_m3_1 w=1.24 l=1.24
xc_27_23 TOP B0 sky130_fd_pr__cap_mim_m3_1 w=1.24 l=1.24
xc_28_23 TOP B0 sky130_fd_pr__cap_mim_m3_1 w=1.24 l=1.24
xc_29_23 TOP B0 sky130_fd_pr__cap_mim_m3_1 w=1.24 l=1.24
xc_30_23 TOP B0 sky130_fd_pr__cap_mim_m3_1 w=1.24 l=1.24
xc_31_23 TOP B0 sky130_fd_pr__cap_mim_m3_1 w=1.24 l=1.24
xc_32_23 TOP B0 sky130_fd_pr__cap_mim_m3_1 w=1.24 l=1.24
xc_33_23 VSS VSS sky130_fd_pr__cap_mim_m3_1 w=1.24 l=1.24
xc_0_24 VSS VSS sky130_fd_pr__cap_mim_m3_1 w=1.24 l=1.24
xc_1_24 TOP B0 sky130_fd_pr__cap_mim_m3_1 w=1.24 l=1.24
xc_2_24 TOP B0 sky130_fd_pr__cap_mim_m3_1 w=1.24 l=1.24
xc_3_24 TOP B0 sky130_fd_pr__cap_mim_m3_1 w=1.24 l=1.24
xc_4_24 TOP B0 sky130_fd_pr__cap_mim_m3_1 w=1.24 l=1.24
xc_5_24 TOP B0 sky130_fd_pr__cap_mim_m3_1 w=1.24 l=1.24
xc_6_24 TOP B0 sky130_fd_pr__cap_mim_m3_1 w=1.24 l=1.24
xc_7_24 TOP B0 sky130_fd_pr__cap_mim_m3_1 w=1.24 l=1.24
xc_8_24 TOP B0 sky130_fd_pr__cap_mim_m3_1 w=1.24 l=1.24
xc_9_24 TOP B1 sky130_fd_pr__cap_mim_m3_1 w=1.24 l=1.24
xc_10_24 TOP B1 sky130_fd_pr__cap_mim_m3_1 w=1.24 l=1.24
xc_11_24 TOP B1 sky130_fd_pr__cap_mim_m3_1 w=1.24 l=1.24
xc_12_24 TOP B1 sky130_fd_pr__cap_mim_m3_1 w=1.24 l=1.24
xc_13_24 TOP B2 sky130_fd_pr__cap_mim_m3_1 w=1.24 l=1.24
xc_14_24 TOP B2 sky130_fd_pr__cap_mim_m3_1 w=1.24 l=1.24
xc_15_24 TOP B3 sky130_fd_pr__cap_mim_m3_1 w=1.24 l=1.24
xc_16_24 TOP B5 sky130_fd_pr__cap_mim_m3_1 w=1.24 l=1.24
xc_17_24 TOP B5 sky130_fd_pr__cap_mim_m3_1 w=1.24 l=1.24
xc_18_24 TOP B3 sky130_fd_pr__cap_mim_m3_1 w=1.24 l=1.24
xc_19_24 TOP B2 sky130_fd_pr__cap_mim_m3_1 w=1.24 l=1.24
xc_20_24 TOP B2 sky130_fd_pr__cap_mim_m3_1 w=1.24 l=1.24
xc_21_24 TOP B1 sky130_fd_pr__cap_mim_m3_1 w=1.24 l=1.24
xc_22_24 TOP B1 sky130_fd_pr__cap_mim_m3_1 w=1.24 l=1.24
xc_23_24 TOP B1 sky130_fd_pr__cap_mim_m3_1 w=1.24 l=1.24
xc_24_24 TOP B1 sky130_fd_pr__cap_mim_m3_1 w=1.24 l=1.24
xc_25_24 TOP B0 sky130_fd_pr__cap_mim_m3_1 w=1.24 l=1.24
xc_26_24 TOP B0 sky130_fd_pr__cap_mim_m3_1 w=1.24 l=1.24
xc_27_24 TOP B0 sky130_fd_pr__cap_mim_m3_1 w=1.24 l=1.24
xc_28_24 TOP B0 sky130_fd_pr__cap_mim_m3_1 w=1.24 l=1.24
xc_29_24 TOP B0 sky130_fd_pr__cap_mim_m3_1 w=1.24 l=1.24
xc_30_24 TOP B0 sky130_fd_pr__cap_mim_m3_1 w=1.24 l=1.24
xc_31_24 TOP B0 sky130_fd_pr__cap_mim_m3_1 w=1.24 l=1.24
xc_32_24 TOP B0 sky130_fd_pr__cap_mim_m3_1 w=1.24 l=1.24
xc_33_24 VSS VSS sky130_fd_pr__cap_mim_m3_1 w=1.24 l=1.24
xc_0_25 VSS VSS sky130_fd_pr__cap_mim_m3_1 w=1.24 l=1.24
xc_1_25 TOP B0 sky130_fd_pr__cap_mim_m3_1 w=1.24 l=1.24
xc_2_25 TOP B0 sky130_fd_pr__cap_mim_m3_1 w=1.24 l=1.24
xc_3_25 TOP B0 sky130_fd_pr__cap_mim_m3_1 w=1.24 l=1.24
xc_4_25 TOP B0 sky130_fd_pr__cap_mim_m3_1 w=1.24 l=1.24
xc_5_25 TOP B0 sky130_fd_pr__cap_mim_m3_1 w=1.24 l=1.24
xc_6_25 TOP B0 sky130_fd_pr__cap_mim_m3_1 w=1.24 l=1.24
xc_7_25 TOP B0 sky130_fd_pr__cap_mim_m3_1 w=1.24 l=1.24
xc_8_25 TOP B0 sky130_fd_pr__cap_mim_m3_1 w=1.24 l=1.24
xc_9_25 TOP B1 sky130_fd_pr__cap_mim_m3_1 w=1.24 l=1.24
xc_10_25 TOP B1 sky130_fd_pr__cap_mim_m3_1 w=1.24 l=1.24
xc_11_25 TOP B1 sky130_fd_pr__cap_mim_m3_1 w=1.24 l=1.24
xc_12_25 TOP B1 sky130_fd_pr__cap_mim_m3_1 w=1.24 l=1.24
xc_13_25 TOP B2 sky130_fd_pr__cap_mim_m3_1 w=1.24 l=1.24
xc_14_25 TOP B2 sky130_fd_pr__cap_mim_m3_1 w=1.24 l=1.24
xc_15_25 TOP B3 sky130_fd_pr__cap_mim_m3_1 w=1.24 l=1.24
xc_16_25 TOP B4 sky130_fd_pr__cap_mim_m3_1 w=1.24 l=1.24
xc_17_25 TOP B4 sky130_fd_pr__cap_mim_m3_1 w=1.24 l=1.24
xc_18_25 TOP B3 sky130_fd_pr__cap_mim_m3_1 w=1.24 l=1.24
xc_19_25 TOP B2 sky130_fd_pr__cap_mim_m3_1 w=1.24 l=1.24
xc_20_25 TOP B2 sky130_fd_pr__cap_mim_m3_1 w=1.24 l=1.24
xc_21_25 TOP B1 sky130_fd_pr__cap_mim_m3_1 w=1.24 l=1.24
xc_22_25 TOP B1 sky130_fd_pr__cap_mim_m3_1 w=1.24 l=1.24
xc_23_25 TOP B1 sky130_fd_pr__cap_mim_m3_1 w=1.24 l=1.24
xc_24_25 TOP B1 sky130_fd_pr__cap_mim_m3_1 w=1.24 l=1.24
xc_25_25 TOP B0 sky130_fd_pr__cap_mim_m3_1 w=1.24 l=1.24
xc_26_25 TOP B0 sky130_fd_pr__cap_mim_m3_1 w=1.24 l=1.24
xc_27_25 TOP B0 sky130_fd_pr__cap_mim_m3_1 w=1.24 l=1.24
xc_28_25 TOP B0 sky130_fd_pr__cap_mim_m3_1 w=1.24 l=1.24
xc_29_25 TOP B0 sky130_fd_pr__cap_mim_m3_1 w=1.24 l=1.24
xc_30_25 TOP B0 sky130_fd_pr__cap_mim_m3_1 w=1.24 l=1.24
xc_31_25 TOP B0 sky130_fd_pr__cap_mim_m3_1 w=1.24 l=1.24
xc_32_25 TOP B0 sky130_fd_pr__cap_mim_m3_1 w=1.24 l=1.24
xc_33_25 VSS VSS sky130_fd_pr__cap_mim_m3_1 w=1.24 l=1.24
xc_0_26 VSS VSS sky130_fd_pr__cap_mim_m3_1 w=1.24 l=1.24
xc_1_26 TOP B0 sky130_fd_pr__cap_mim_m3_1 w=1.24 l=1.24
xc_2_26 TOP B0 sky130_fd_pr__cap_mim_m3_1 w=1.24 l=1.24
xc_3_26 TOP B0 sky130_fd_pr__cap_mim_m3_1 w=1.24 l=1.24
xc_4_26 TOP B0 sky130_fd_pr__cap_mim_m3_1 w=1.24 l=1.24
xc_5_26 TOP B0 sky130_fd_pr__cap_mim_m3_1 w=1.24 l=1.24
xc_6_26 TOP B0 sky130_fd_pr__cap_mim_m3_1 w=1.24 l=1.24
xc_7_26 TOP B0 sky130_fd_pr__cap_mim_m3_1 w=1.24 l=1.24
xc_8_26 TOP B0 sky130_fd_pr__cap_mim_m3_1 w=1.24 l=1.24
xc_9_26 TOP B1 sky130_fd_pr__cap_mim_m3_1 w=1.24 l=1.24
xc_10_26 TOP B1 sky130_fd_pr__cap_mim_m3_1 w=1.24 l=1.24
xc_11_26 TOP B1 sky130_fd_pr__cap_mim_m3_1 w=1.24 l=1.24
xc_12_26 TOP B1 sky130_fd_pr__cap_mim_m3_1 w=1.24 l=1.24
xc_13_26 TOP B2 sky130_fd_pr__cap_mim_m3_1 w=1.24 l=1.24
xc_14_26 TOP B2 sky130_fd_pr__cap_mim_m3_1 w=1.24 l=1.24
xc_15_26 TOP B3 sky130_fd_pr__cap_mim_m3_1 w=1.24 l=1.24
xc_16_26 TOP B4 sky130_fd_pr__cap_mim_m3_1 w=1.24 l=1.24
xc_17_26 TOP B4 sky130_fd_pr__cap_mim_m3_1 w=1.24 l=1.24
xc_18_26 TOP B3 sky130_fd_pr__cap_mim_m3_1 w=1.24 l=1.24
xc_19_26 TOP B2 sky130_fd_pr__cap_mim_m3_1 w=1.24 l=1.24
xc_20_26 TOP B2 sky130_fd_pr__cap_mim_m3_1 w=1.24 l=1.24
xc_21_26 TOP B1 sky130_fd_pr__cap_mim_m3_1 w=1.24 l=1.24
xc_22_26 TOP B1 sky130_fd_pr__cap_mim_m3_1 w=1.24 l=1.24
xc_23_26 TOP B1 sky130_fd_pr__cap_mim_m3_1 w=1.24 l=1.24
xc_24_26 TOP B1 sky130_fd_pr__cap_mim_m3_1 w=1.24 l=1.24
xc_25_26 TOP B0 sky130_fd_pr__cap_mim_m3_1 w=1.24 l=1.24
xc_26_26 TOP B0 sky130_fd_pr__cap_mim_m3_1 w=1.24 l=1.24
xc_27_26 TOP B0 sky130_fd_pr__cap_mim_m3_1 w=1.24 l=1.24
xc_28_26 TOP B0 sky130_fd_pr__cap_mim_m3_1 w=1.24 l=1.24
xc_29_26 TOP B0 sky130_fd_pr__cap_mim_m3_1 w=1.24 l=1.24
xc_30_26 TOP B0 sky130_fd_pr__cap_mim_m3_1 w=1.24 l=1.24
xc_31_26 TOP B0 sky130_fd_pr__cap_mim_m3_1 w=1.24 l=1.24
xc_32_26 TOP B0 sky130_fd_pr__cap_mim_m3_1 w=1.24 l=1.24
xc_33_26 VSS VSS sky130_fd_pr__cap_mim_m3_1 w=1.24 l=1.24
xc_0_27 VSS VSS sky130_fd_pr__cap_mim_m3_1 w=1.24 l=1.24
xc_1_27 TOP B0 sky130_fd_pr__cap_mim_m3_1 w=1.24 l=1.24
xc_2_27 TOP B0 sky130_fd_pr__cap_mim_m3_1 w=1.24 l=1.24
xc_3_27 TOP B0 sky130_fd_pr__cap_mim_m3_1 w=1.24 l=1.24
xc_4_27 TOP B0 sky130_fd_pr__cap_mim_m3_1 w=1.24 l=1.24
xc_5_27 TOP B0 sky130_fd_pr__cap_mim_m3_1 w=1.24 l=1.24
xc_6_27 TOP B0 sky130_fd_pr__cap_mim_m3_1 w=1.24 l=1.24
xc_7_27 TOP B0 sky130_fd_pr__cap_mim_m3_1 w=1.24 l=1.24
xc_8_27 TOP B0 sky130_fd_pr__cap_mim_m3_1 w=1.24 l=1.24
xc_9_27 TOP B1 sky130_fd_pr__cap_mim_m3_1 w=1.24 l=1.24
xc_10_27 TOP B1 sky130_fd_pr__cap_mim_m3_1 w=1.24 l=1.24
xc_11_27 TOP B1 sky130_fd_pr__cap_mim_m3_1 w=1.24 l=1.24
xc_12_27 TOP B1 sky130_fd_pr__cap_mim_m3_1 w=1.24 l=1.24
xc_13_27 TOP B2 sky130_fd_pr__cap_mim_m3_1 w=1.24 l=1.24
xc_14_27 TOP B2 sky130_fd_pr__cap_mim_m3_1 w=1.24 l=1.24
xc_15_27 TOP B3 sky130_fd_pr__cap_mim_m3_1 w=1.24 l=1.24
xc_16_27 TOP B4 sky130_fd_pr__cap_mim_m3_1 w=1.24 l=1.24
xc_17_27 TOP B4 sky130_fd_pr__cap_mim_m3_1 w=1.24 l=1.24
xc_18_27 TOP B3 sky130_fd_pr__cap_mim_m3_1 w=1.24 l=1.24
xc_19_27 TOP B2 sky130_fd_pr__cap_mim_m3_1 w=1.24 l=1.24
xc_20_27 TOP B2 sky130_fd_pr__cap_mim_m3_1 w=1.24 l=1.24
xc_21_27 TOP B1 sky130_fd_pr__cap_mim_m3_1 w=1.24 l=1.24
xc_22_27 TOP B1 sky130_fd_pr__cap_mim_m3_1 w=1.24 l=1.24
xc_23_27 TOP B1 sky130_fd_pr__cap_mim_m3_1 w=1.24 l=1.24
xc_24_27 TOP B1 sky130_fd_pr__cap_mim_m3_1 w=1.24 l=1.24
xc_25_27 TOP B0 sky130_fd_pr__cap_mim_m3_1 w=1.24 l=1.24
xc_26_27 TOP B0 sky130_fd_pr__cap_mim_m3_1 w=1.24 l=1.24
xc_27_27 TOP B0 sky130_fd_pr__cap_mim_m3_1 w=1.24 l=1.24
xc_28_27 TOP B0 sky130_fd_pr__cap_mim_m3_1 w=1.24 l=1.24
xc_29_27 TOP B0 sky130_fd_pr__cap_mim_m3_1 w=1.24 l=1.24
xc_30_27 TOP B0 sky130_fd_pr__cap_mim_m3_1 w=1.24 l=1.24
xc_31_27 TOP B0 sky130_fd_pr__cap_mim_m3_1 w=1.24 l=1.24
xc_32_27 TOP B0 sky130_fd_pr__cap_mim_m3_1 w=1.24 l=1.24
xc_33_27 VSS VSS sky130_fd_pr__cap_mim_m3_1 w=1.24 l=1.24
xc_0_28 VSS VSS sky130_fd_pr__cap_mim_m3_1 w=1.24 l=1.24
xc_1_28 TOP B0 sky130_fd_pr__cap_mim_m3_1 w=1.24 l=1.24
xc_2_28 TOP B0 sky130_fd_pr__cap_mim_m3_1 w=1.24 l=1.24
xc_3_28 TOP B0 sky130_fd_pr__cap_mim_m3_1 w=1.24 l=1.24
xc_4_28 TOP B0 sky130_fd_pr__cap_mim_m3_1 w=1.24 l=1.24
xc_5_28 TOP B0 sky130_fd_pr__cap_mim_m3_1 w=1.24 l=1.24
xc_6_28 TOP B0 sky130_fd_pr__cap_mim_m3_1 w=1.24 l=1.24
xc_7_28 TOP B0 sky130_fd_pr__cap_mim_m3_1 w=1.24 l=1.24
xc_8_28 TOP B0 sky130_fd_pr__cap_mim_m3_1 w=1.24 l=1.24
xc_9_28 TOP B1 sky130_fd_pr__cap_mim_m3_1 w=1.24 l=1.24
xc_10_28 TOP B1 sky130_fd_pr__cap_mim_m3_1 w=1.24 l=1.24
xc_11_28 TOP B1 sky130_fd_pr__cap_mim_m3_1 w=1.24 l=1.24
xc_12_28 TOP B1 sky130_fd_pr__cap_mim_m3_1 w=1.24 l=1.24
xc_13_28 TOP B2 sky130_fd_pr__cap_mim_m3_1 w=1.24 l=1.24
xc_14_28 TOP B2 sky130_fd_pr__cap_mim_m3_1 w=1.24 l=1.24
xc_15_28 TOP B3 sky130_fd_pr__cap_mim_m3_1 w=1.24 l=1.24
xc_16_28 TOP B4 sky130_fd_pr__cap_mim_m3_1 w=1.24 l=1.24
xc_17_28 TOP B4 sky130_fd_pr__cap_mim_m3_1 w=1.24 l=1.24
xc_18_28 TOP B3 sky130_fd_pr__cap_mim_m3_1 w=1.24 l=1.24
xc_19_28 TOP B2 sky130_fd_pr__cap_mim_m3_1 w=1.24 l=1.24
xc_20_28 TOP B2 sky130_fd_pr__cap_mim_m3_1 w=1.24 l=1.24
xc_21_28 TOP B1 sky130_fd_pr__cap_mim_m3_1 w=1.24 l=1.24
xc_22_28 TOP B1 sky130_fd_pr__cap_mim_m3_1 w=1.24 l=1.24
xc_23_28 TOP B1 sky130_fd_pr__cap_mim_m3_1 w=1.24 l=1.24
xc_24_28 TOP B1 sky130_fd_pr__cap_mim_m3_1 w=1.24 l=1.24
xc_25_28 TOP B0 sky130_fd_pr__cap_mim_m3_1 w=1.24 l=1.24
xc_26_28 TOP B0 sky130_fd_pr__cap_mim_m3_1 w=1.24 l=1.24
xc_27_28 TOP B0 sky130_fd_pr__cap_mim_m3_1 w=1.24 l=1.24
xc_28_28 TOP B0 sky130_fd_pr__cap_mim_m3_1 w=1.24 l=1.24
xc_29_28 TOP B0 sky130_fd_pr__cap_mim_m3_1 w=1.24 l=1.24
xc_30_28 TOP B0 sky130_fd_pr__cap_mim_m3_1 w=1.24 l=1.24
xc_31_28 TOP B0 sky130_fd_pr__cap_mim_m3_1 w=1.24 l=1.24
xc_32_28 TOP B0 sky130_fd_pr__cap_mim_m3_1 w=1.24 l=1.24
xc_33_28 VSS VSS sky130_fd_pr__cap_mim_m3_1 w=1.24 l=1.24
xc_0_29 VSS VSS sky130_fd_pr__cap_mim_m3_1 w=1.24 l=1.24
xc_1_29 TOP B0 sky130_fd_pr__cap_mim_m3_1 w=1.24 l=1.24
xc_2_29 TOP B0 sky130_fd_pr__cap_mim_m3_1 w=1.24 l=1.24
xc_3_29 TOP B0 sky130_fd_pr__cap_mim_m3_1 w=1.24 l=1.24
xc_4_29 TOP B0 sky130_fd_pr__cap_mim_m3_1 w=1.24 l=1.24
xc_5_29 TOP B0 sky130_fd_pr__cap_mim_m3_1 w=1.24 l=1.24
xc_6_29 TOP B0 sky130_fd_pr__cap_mim_m3_1 w=1.24 l=1.24
xc_7_29 TOP B0 sky130_fd_pr__cap_mim_m3_1 w=1.24 l=1.24
xc_8_29 TOP B0 sky130_fd_pr__cap_mim_m3_1 w=1.24 l=1.24
xc_9_29 TOP B1 sky130_fd_pr__cap_mim_m3_1 w=1.24 l=1.24
xc_10_29 TOP B1 sky130_fd_pr__cap_mim_m3_1 w=1.24 l=1.24
xc_11_29 TOP B1 sky130_fd_pr__cap_mim_m3_1 w=1.24 l=1.24
xc_12_29 TOP B1 sky130_fd_pr__cap_mim_m3_1 w=1.24 l=1.24
xc_13_29 TOP B2 sky130_fd_pr__cap_mim_m3_1 w=1.24 l=1.24
xc_14_29 TOP B2 sky130_fd_pr__cap_mim_m3_1 w=1.24 l=1.24
xc_15_29 TOP B3 sky130_fd_pr__cap_mim_m3_1 w=1.24 l=1.24
xc_16_29 TOP B4 sky130_fd_pr__cap_mim_m3_1 w=1.24 l=1.24
xc_17_29 TOP B4 sky130_fd_pr__cap_mim_m3_1 w=1.24 l=1.24
xc_18_29 TOP B3 sky130_fd_pr__cap_mim_m3_1 w=1.24 l=1.24
xc_19_29 TOP B2 sky130_fd_pr__cap_mim_m3_1 w=1.24 l=1.24
xc_20_29 TOP B2 sky130_fd_pr__cap_mim_m3_1 w=1.24 l=1.24
xc_21_29 TOP B1 sky130_fd_pr__cap_mim_m3_1 w=1.24 l=1.24
xc_22_29 TOP B1 sky130_fd_pr__cap_mim_m3_1 w=1.24 l=1.24
xc_23_29 TOP B1 sky130_fd_pr__cap_mim_m3_1 w=1.24 l=1.24
xc_24_29 TOP B1 sky130_fd_pr__cap_mim_m3_1 w=1.24 l=1.24
xc_25_29 TOP B0 sky130_fd_pr__cap_mim_m3_1 w=1.24 l=1.24
xc_26_29 TOP B0 sky130_fd_pr__cap_mim_m3_1 w=1.24 l=1.24
xc_27_29 TOP B0 sky130_fd_pr__cap_mim_m3_1 w=1.24 l=1.24
xc_28_29 TOP B0 sky130_fd_pr__cap_mim_m3_1 w=1.24 l=1.24
xc_29_29 TOP B0 sky130_fd_pr__cap_mim_m3_1 w=1.24 l=1.24
xc_30_29 TOP B0 sky130_fd_pr__cap_mim_m3_1 w=1.24 l=1.24
xc_31_29 TOP B0 sky130_fd_pr__cap_mim_m3_1 w=1.24 l=1.24
xc_32_29 TOP B0 sky130_fd_pr__cap_mim_m3_1 w=1.24 l=1.24
xc_33_29 VSS VSS sky130_fd_pr__cap_mim_m3_1 w=1.24 l=1.24
xc_0_30 VSS VSS sky130_fd_pr__cap_mim_m3_1 w=1.24 l=1.24
xc_1_30 TOP B0 sky130_fd_pr__cap_mim_m3_1 w=1.24 l=1.24
xc_2_30 TOP B0 sky130_fd_pr__cap_mim_m3_1 w=1.24 l=1.24
xc_3_30 TOP B0 sky130_fd_pr__cap_mim_m3_1 w=1.24 l=1.24
xc_4_30 TOP B0 sky130_fd_pr__cap_mim_m3_1 w=1.24 l=1.24
xc_5_30 TOP B0 sky130_fd_pr__cap_mim_m3_1 w=1.24 l=1.24
xc_6_30 TOP B0 sky130_fd_pr__cap_mim_m3_1 w=1.24 l=1.24
xc_7_30 TOP B0 sky130_fd_pr__cap_mim_m3_1 w=1.24 l=1.24
xc_8_30 TOP B0 sky130_fd_pr__cap_mim_m3_1 w=1.24 l=1.24
xc_9_30 TOP B1 sky130_fd_pr__cap_mim_m3_1 w=1.24 l=1.24
xc_10_30 TOP B1 sky130_fd_pr__cap_mim_m3_1 w=1.24 l=1.24
xc_11_30 TOP B1 sky130_fd_pr__cap_mim_m3_1 w=1.24 l=1.24
xc_12_30 TOP B1 sky130_fd_pr__cap_mim_m3_1 w=1.24 l=1.24
xc_13_30 TOP B2 sky130_fd_pr__cap_mim_m3_1 w=1.24 l=1.24
xc_14_30 TOP B2 sky130_fd_pr__cap_mim_m3_1 w=1.24 l=1.24
xc_15_30 TOP B3 sky130_fd_pr__cap_mim_m3_1 w=1.24 l=1.24
xc_16_30 TOP B4 sky130_fd_pr__cap_mim_m3_1 w=1.24 l=1.24
xc_17_30 TOP B4 sky130_fd_pr__cap_mim_m3_1 w=1.24 l=1.24
xc_18_30 TOP B3 sky130_fd_pr__cap_mim_m3_1 w=1.24 l=1.24
xc_19_30 TOP B2 sky130_fd_pr__cap_mim_m3_1 w=1.24 l=1.24
xc_20_30 TOP B2 sky130_fd_pr__cap_mim_m3_1 w=1.24 l=1.24
xc_21_30 TOP B1 sky130_fd_pr__cap_mim_m3_1 w=1.24 l=1.24
xc_22_30 TOP B1 sky130_fd_pr__cap_mim_m3_1 w=1.24 l=1.24
xc_23_30 TOP B1 sky130_fd_pr__cap_mim_m3_1 w=1.24 l=1.24
xc_24_30 TOP B1 sky130_fd_pr__cap_mim_m3_1 w=1.24 l=1.24
xc_25_30 TOP B0 sky130_fd_pr__cap_mim_m3_1 w=1.24 l=1.24
xc_26_30 TOP B0 sky130_fd_pr__cap_mim_m3_1 w=1.24 l=1.24
xc_27_30 TOP B0 sky130_fd_pr__cap_mim_m3_1 w=1.24 l=1.24
xc_28_30 TOP B0 sky130_fd_pr__cap_mim_m3_1 w=1.24 l=1.24
xc_29_30 TOP B0 sky130_fd_pr__cap_mim_m3_1 w=1.24 l=1.24
xc_30_30 TOP B0 sky130_fd_pr__cap_mim_m3_1 w=1.24 l=1.24
xc_31_30 TOP B0 sky130_fd_pr__cap_mim_m3_1 w=1.24 l=1.24
xc_32_30 TOP B0 sky130_fd_pr__cap_mim_m3_1 w=1.24 l=1.24
xc_33_30 VSS VSS sky130_fd_pr__cap_mim_m3_1 w=1.24 l=1.24
xc_0_31 VSS VSS sky130_fd_pr__cap_mim_m3_1 w=1.24 l=1.24
xc_1_31 TOP B0 sky130_fd_pr__cap_mim_m3_1 w=1.24 l=1.24
xc_2_31 TOP B0 sky130_fd_pr__cap_mim_m3_1 w=1.24 l=1.24
xc_3_31 TOP B0 sky130_fd_pr__cap_mim_m3_1 w=1.24 l=1.24
xc_4_31 TOP B0 sky130_fd_pr__cap_mim_m3_1 w=1.24 l=1.24
xc_5_31 TOP B0 sky130_fd_pr__cap_mim_m3_1 w=1.24 l=1.24
xc_6_31 TOP B0 sky130_fd_pr__cap_mim_m3_1 w=1.24 l=1.24
xc_7_31 TOP B0 sky130_fd_pr__cap_mim_m3_1 w=1.24 l=1.24
xc_8_31 TOP B0 sky130_fd_pr__cap_mim_m3_1 w=1.24 l=1.24
xc_9_31 TOP B1 sky130_fd_pr__cap_mim_m3_1 w=1.24 l=1.24
xc_10_31 TOP B1 sky130_fd_pr__cap_mim_m3_1 w=1.24 l=1.24
xc_11_31 TOP B1 sky130_fd_pr__cap_mim_m3_1 w=1.24 l=1.24
xc_12_31 TOP B1 sky130_fd_pr__cap_mim_m3_1 w=1.24 l=1.24
xc_13_31 TOP B2 sky130_fd_pr__cap_mim_m3_1 w=1.24 l=1.24
xc_14_31 TOP B2 sky130_fd_pr__cap_mim_m3_1 w=1.24 l=1.24
xc_15_31 TOP B3 sky130_fd_pr__cap_mim_m3_1 w=1.24 l=1.24
xc_16_31 TOP B4 sky130_fd_pr__cap_mim_m3_1 w=1.24 l=1.24
xc_17_31 TOP B4 sky130_fd_pr__cap_mim_m3_1 w=1.24 l=1.24
xc_18_31 TOP B3 sky130_fd_pr__cap_mim_m3_1 w=1.24 l=1.24
xc_19_31 TOP B2 sky130_fd_pr__cap_mim_m3_1 w=1.24 l=1.24
xc_20_31 TOP B2 sky130_fd_pr__cap_mim_m3_1 w=1.24 l=1.24
xc_21_31 TOP B1 sky130_fd_pr__cap_mim_m3_1 w=1.24 l=1.24
xc_22_31 TOP B1 sky130_fd_pr__cap_mim_m3_1 w=1.24 l=1.24
xc_23_31 TOP B1 sky130_fd_pr__cap_mim_m3_1 w=1.24 l=1.24
xc_24_31 TOP B1 sky130_fd_pr__cap_mim_m3_1 w=1.24 l=1.24
xc_25_31 TOP B0 sky130_fd_pr__cap_mim_m3_1 w=1.24 l=1.24
xc_26_31 TOP B0 sky130_fd_pr__cap_mim_m3_1 w=1.24 l=1.24
xc_27_31 TOP B0 sky130_fd_pr__cap_mim_m3_1 w=1.24 l=1.24
xc_28_31 TOP B0 sky130_fd_pr__cap_mim_m3_1 w=1.24 l=1.24
xc_29_31 TOP B0 sky130_fd_pr__cap_mim_m3_1 w=1.24 l=1.24
xc_30_31 TOP B0 sky130_fd_pr__cap_mim_m3_1 w=1.24 l=1.24
xc_31_31 TOP B0 sky130_fd_pr__cap_mim_m3_1 w=1.24 l=1.24
xc_32_31 TOP B0 sky130_fd_pr__cap_mim_m3_1 w=1.24 l=1.24
xc_33_31 VSS VSS sky130_fd_pr__cap_mim_m3_1 w=1.24 l=1.24
xc_0_32 VSS VSS sky130_fd_pr__cap_mim_m3_1 w=1.24 l=1.24
xc_1_32 TOP B0 sky130_fd_pr__cap_mim_m3_1 w=1.24 l=1.24
xc_2_32 TOP B0 sky130_fd_pr__cap_mim_m3_1 w=1.24 l=1.24
xc_3_32 TOP B0 sky130_fd_pr__cap_mim_m3_1 w=1.24 l=1.24
xc_4_32 TOP B0 sky130_fd_pr__cap_mim_m3_1 w=1.24 l=1.24
xc_5_32 TOP B0 sky130_fd_pr__cap_mim_m3_1 w=1.24 l=1.24
xc_6_32 TOP B0 sky130_fd_pr__cap_mim_m3_1 w=1.24 l=1.24
xc_7_32 TOP B0 sky130_fd_pr__cap_mim_m3_1 w=1.24 l=1.24
xc_8_32 TOP B0 sky130_fd_pr__cap_mim_m3_1 w=1.24 l=1.24
xc_9_32 TOP B1 sky130_fd_pr__cap_mim_m3_1 w=1.24 l=1.24
xc_10_32 TOP B1 sky130_fd_pr__cap_mim_m3_1 w=1.24 l=1.24
xc_11_32 TOP B1 sky130_fd_pr__cap_mim_m3_1 w=1.24 l=1.24
xc_12_32 TOP B1 sky130_fd_pr__cap_mim_m3_1 w=1.24 l=1.24
xc_13_32 TOP B2 sky130_fd_pr__cap_mim_m3_1 w=1.24 l=1.24
xc_14_32 TOP B2 sky130_fd_pr__cap_mim_m3_1 w=1.24 l=1.24
xc_15_32 TOP B3 sky130_fd_pr__cap_mim_m3_1 w=1.24 l=1.24
xc_16_32 TOP B4 sky130_fd_pr__cap_mim_m3_1 w=1.24 l=1.24
xc_17_32 TOP B4 sky130_fd_pr__cap_mim_m3_1 w=1.24 l=1.24
xc_18_32 TOP B3 sky130_fd_pr__cap_mim_m3_1 w=1.24 l=1.24
xc_19_32 TOP B2 sky130_fd_pr__cap_mim_m3_1 w=1.24 l=1.24
xc_20_32 TOP B2 sky130_fd_pr__cap_mim_m3_1 w=1.24 l=1.24
xc_21_32 TOP B1 sky130_fd_pr__cap_mim_m3_1 w=1.24 l=1.24
xc_22_32 TOP B1 sky130_fd_pr__cap_mim_m3_1 w=1.24 l=1.24
xc_23_32 TOP B1 sky130_fd_pr__cap_mim_m3_1 w=1.24 l=1.24
xc_24_32 TOP B1 sky130_fd_pr__cap_mim_m3_1 w=1.24 l=1.24
xc_25_32 TOP B0 sky130_fd_pr__cap_mim_m3_1 w=1.24 l=1.24
xc_26_32 TOP B0 sky130_fd_pr__cap_mim_m3_1 w=1.24 l=1.24
xc_27_32 TOP B0 sky130_fd_pr__cap_mim_m3_1 w=1.24 l=1.24
xc_28_32 TOP B0 sky130_fd_pr__cap_mim_m3_1 w=1.24 l=1.24
xc_29_32 TOP B0 sky130_fd_pr__cap_mim_m3_1 w=1.24 l=1.24
xc_30_32 TOP B0 sky130_fd_pr__cap_mim_m3_1 w=1.24 l=1.24
xc_31_32 TOP B0 sky130_fd_pr__cap_mim_m3_1 w=1.24 l=1.24
xc_32_32 TOP B0 sky130_fd_pr__cap_mim_m3_1 w=1.24 l=1.24
xc_33_32 VSS VSS sky130_fd_pr__cap_mim_m3_1 w=1.24 l=1.24
xc_0_33 VSS VSS sky130_fd_pr__cap_mim_m3_1 w=1.24 l=1.24
xc_1_33 VSS VSS sky130_fd_pr__cap_mim_m3_1 w=1.24 l=1.24
xc_2_33 VSS VSS sky130_fd_pr__cap_mim_m3_1 w=1.24 l=1.24
xc_3_33 VSS VSS sky130_fd_pr__cap_mim_m3_1 w=1.24 l=1.24
xc_4_33 VSS VSS sky130_fd_pr__cap_mim_m3_1 w=1.24 l=1.24
xc_5_33 VSS VSS sky130_fd_pr__cap_mim_m3_1 w=1.24 l=1.24
xc_6_33 VSS VSS sky130_fd_pr__cap_mim_m3_1 w=1.24 l=1.24
xc_7_33 VSS VSS sky130_fd_pr__cap_mim_m3_1 w=1.24 l=1.24
xc_8_33 VSS VSS sky130_fd_pr__cap_mim_m3_1 w=1.24 l=1.24
xc_9_33 VSS VSS sky130_fd_pr__cap_mim_m3_1 w=1.24 l=1.24
xc_10_33 VSS VSS sky130_fd_pr__cap_mim_m3_1 w=1.24 l=1.24
xc_11_33 VSS VSS sky130_fd_pr__cap_mim_m3_1 w=1.24 l=1.24
xc_12_33 VSS VSS sky130_fd_pr__cap_mim_m3_1 w=1.24 l=1.24
xc_13_33 VSS VSS sky130_fd_pr__cap_mim_m3_1 w=1.24 l=1.24
xc_14_33 VSS VSS sky130_fd_pr__cap_mim_m3_1 w=1.24 l=1.24
xc_15_33 VSS VSS sky130_fd_pr__cap_mim_m3_1 w=1.24 l=1.24
xc_16_33 VSS VSS sky130_fd_pr__cap_mim_m3_1 w=1.24 l=1.24
xc_17_33 VSS VSS sky130_fd_pr__cap_mim_m3_1 w=1.24 l=1.24
xc_18_33 VSS VSS sky130_fd_pr__cap_mim_m3_1 w=1.24 l=1.24
xc_19_33 VSS VSS sky130_fd_pr__cap_mim_m3_1 w=1.24 l=1.24
xc_20_33 VSS VSS sky130_fd_pr__cap_mim_m3_1 w=1.24 l=1.24
xc_21_33 VSS VSS sky130_fd_pr__cap_mim_m3_1 w=1.24 l=1.24
xc_22_33 VSS VSS sky130_fd_pr__cap_mim_m3_1 w=1.24 l=1.24
xc_23_33 VSS VSS sky130_fd_pr__cap_mim_m3_1 w=1.24 l=1.24
xc_24_33 VSS VSS sky130_fd_pr__cap_mim_m3_1 w=1.24 l=1.24
xc_25_33 VSS VSS sky130_fd_pr__cap_mim_m3_1 w=1.24 l=1.24
xc_26_33 VSS VSS sky130_fd_pr__cap_mim_m3_1 w=1.24 l=1.24
xc_27_33 VSS VSS sky130_fd_pr__cap_mim_m3_1 w=1.24 l=1.24
xc_28_33 VSS VSS sky130_fd_pr__cap_mim_m3_1 w=1.24 l=1.24
xc_29_33 VSS VSS sky130_fd_pr__cap_mim_m3_1 w=1.24 l=1.24
xc_30_33 VSS VSS sky130_fd_pr__cap_mim_m3_1 w=1.24 l=1.24
xc_31_33 VSS VSS sky130_fd_pr__cap_mim_m3_1 w=1.24 l=1.24
xc_32_33 VSS VSS sky130_fd_pr__cap_mim_m3_1 w=1.24 l=1.24
xc_33_33 VSS VSS sky130_fd_pr__cap_mim_m3_1 w=1.24 l=1.24
.ends cdac_core
