.subckt bank_side VIN TRK TRKB VREFP VREFN VDDA VSS BOT0 BOT1 BOT2 BOT3 BOT4 BOT5 BOT6 BOT7 BOT8 BOT9 BOT10 LO0 LO1 LO2 LO3 LO4 LO5 LO6 LO7 LO8 LO9 LO10 HIB0 HIB1 HIB2 HIB3 HIB4 HIB5 HIB6 HIB7 HIB8 HIB9
xntg0_0 BOT0 TRK VIN VSS sky130_fd_pr__nfet_01v8 w=4.8 l=0.15
xntg0_1 BOT0 TRK VIN VSS sky130_fd_pr__nfet_01v8 w=4.8 l=0.15
xntg0_2 BOT0 TRK VIN VSS sky130_fd_pr__nfet_01v8 w=4.8 l=0.15
xntg0_3 BOT0 TRK VIN VSS sky130_fd_pr__nfet_01v8 w=4.8 l=0.15
xntg0_4 BOT0 TRK VIN VSS sky130_fd_pr__nfet_01v8 w=4.8 l=0.15
xntg0_5 BOT0 TRK VIN VSS sky130_fd_pr__nfet_01v8 w=4.8 l=0.15
xntg0_6 BOT0 TRK VIN VSS sky130_fd_pr__nfet_01v8 w=4.8 l=0.15
xntg0_7 BOT0 TRK VIN VSS sky130_fd_pr__nfet_01v8 w=4.8 l=0.15
xntg0_8 BOT0 TRK VIN VSS sky130_fd_pr__nfet_01v8 w=4.8 l=0.15
xntg0_9 BOT0 TRK VIN VSS sky130_fd_pr__nfet_01v8 w=4.8 l=0.15
xptg0_0 BOT0 TRKB VIN VDDA sky130_fd_pr__pfet_01v8 w=4.8 l=0.15
xptg0_1 BOT0 TRKB VIN VDDA sky130_fd_pr__pfet_01v8 w=4.8 l=0.15
xptg0_2 BOT0 TRKB VIN VDDA sky130_fd_pr__pfet_01v8 w=4.8 l=0.15
xptg0_3 BOT0 TRKB VIN VDDA sky130_fd_pr__pfet_01v8 w=4.8 l=0.15
xptg0_4 BOT0 TRKB VIN VDDA sky130_fd_pr__pfet_01v8 w=4.8 l=0.15
xptg0_5 BOT0 TRKB VIN VDDA sky130_fd_pr__pfet_01v8 w=4.8 l=0.15
xptg0_6 BOT0 TRKB VIN VDDA sky130_fd_pr__pfet_01v8 w=4.8 l=0.15
xptg0_7 BOT0 TRKB VIN VDDA sky130_fd_pr__pfet_01v8 w=4.8 l=0.15
xptg0_8 BOT0 TRKB VIN VDDA sky130_fd_pr__pfet_01v8 w=4.8 l=0.15
xptg0_9 BOT0 TRKB VIN VDDA sky130_fd_pr__pfet_01v8 w=4.8 l=0.15
xptg0_10 BOT0 TRKB VIN VDDA sky130_fd_pr__pfet_01v8 w=4.8 l=0.15
xptg0_11 BOT0 TRKB VIN VDDA sky130_fd_pr__pfet_01v8 w=4.8 l=0.15
xptg0_12 BOT0 TRKB VIN VDDA sky130_fd_pr__pfet_01v8 w=4.8 l=0.15
xptg0_13 BOT0 TRKB VIN VDDA sky130_fd_pr__pfet_01v8 w=4.8 l=0.15
xptg0_14 BOT0 TRKB VIN VDDA sky130_fd_pr__pfet_01v8 w=4.8 l=0.15
xptg0_15 BOT0 TRKB VIN VDDA sky130_fd_pr__pfet_01v8 w=4.8 l=0.15
xptg0_16 BOT0 TRKB VIN VDDA sky130_fd_pr__pfet_01v8 w=4.8 l=0.15
xptg0_17 BOT0 TRKB VIN VDDA sky130_fd_pr__pfet_01v8 w=4.8 l=0.15
xptg0_18 BOT0 TRKB VIN VDDA sky130_fd_pr__pfet_01v8 w=4.8 l=0.15
xptg0_19 BOT0 TRKB VIN VDDA sky130_fd_pr__pfet_01v8 w=4.8 l=0.15
xndr0_0 BOT0 LO0 VREFN VSS sky130_fd_pr__nfet_01v8 w=3 l=0.15
xndr0_1 BOT0 LO0 VREFN VSS sky130_fd_pr__nfet_01v8 w=3 l=0.15
xpdr0_0 BOT0 HIB0 VREFP VDDA sky130_fd_pr__pfet_01v8 w=5 l=0.15
xpdr0_1 BOT0 HIB0 VREFP VDDA sky130_fd_pr__pfet_01v8 w=5 l=0.15
xpdr0_2 BOT0 HIB0 VREFP VDDA sky130_fd_pr__pfet_01v8 w=5 l=0.15
xpdr0_3 BOT0 HIB0 VREFP VDDA sky130_fd_pr__pfet_01v8 w=5 l=0.15
xpdr0_4 BOT0 HIB0 VREFP VDDA sky130_fd_pr__pfet_01v8 w=5 l=0.15
xpdr0_5 BOT0 HIB0 VREFP VDDA sky130_fd_pr__pfet_01v8 w=5 l=0.15
xntg1_0 BOT1 TRK VIN VSS sky130_fd_pr__nfet_01v8 w=4.8 l=0.15
xntg1_1 BOT1 TRK VIN VSS sky130_fd_pr__nfet_01v8 w=4.8 l=0.15
xntg1_2 BOT1 TRK VIN VSS sky130_fd_pr__nfet_01v8 w=4.8 l=0.15
xntg1_3 BOT1 TRK VIN VSS sky130_fd_pr__nfet_01v8 w=4.8 l=0.15
xntg1_4 BOT1 TRK VIN VSS sky130_fd_pr__nfet_01v8 w=4.8 l=0.15
xptg1_0 BOT1 TRKB VIN VDDA sky130_fd_pr__pfet_01v8 w=4.8 l=0.15
xptg1_1 BOT1 TRKB VIN VDDA sky130_fd_pr__pfet_01v8 w=4.8 l=0.15
xptg1_2 BOT1 TRKB VIN VDDA sky130_fd_pr__pfet_01v8 w=4.8 l=0.15
xptg1_3 BOT1 TRKB VIN VDDA sky130_fd_pr__pfet_01v8 w=4.8 l=0.15
xptg1_4 BOT1 TRKB VIN VDDA sky130_fd_pr__pfet_01v8 w=4.8 l=0.15
xptg1_5 BOT1 TRKB VIN VDDA sky130_fd_pr__pfet_01v8 w=4.8 l=0.15
xptg1_6 BOT1 TRKB VIN VDDA sky130_fd_pr__pfet_01v8 w=4.8 l=0.15
xptg1_7 BOT1 TRKB VIN VDDA sky130_fd_pr__pfet_01v8 w=4.8 l=0.15
xptg1_8 BOT1 TRKB VIN VDDA sky130_fd_pr__pfet_01v8 w=4.8 l=0.15
xptg1_9 BOT1 TRKB VIN VDDA sky130_fd_pr__pfet_01v8 w=4.8 l=0.15
xndr1_0 BOT1 LO1 VREFN VSS sky130_fd_pr__nfet_01v8 w=3 l=0.15
xpdr1_0 BOT1 HIB1 VREFP VDDA sky130_fd_pr__pfet_01v8 w=5 l=0.15
xpdr1_1 BOT1 HIB1 VREFP VDDA sky130_fd_pr__pfet_01v8 w=5 l=0.15
xpdr1_2 BOT1 HIB1 VREFP VDDA sky130_fd_pr__pfet_01v8 w=5 l=0.15
xntg2_0 BOT2 TRK VIN VSS sky130_fd_pr__nfet_01v8 w=4 l=0.15
xntg2_1 BOT2 TRK VIN VSS sky130_fd_pr__nfet_01v8 w=4 l=0.15
xntg2_2 BOT2 TRK VIN VSS sky130_fd_pr__nfet_01v8 w=4 l=0.15
xptg2_0 BOT2 TRKB VIN VDDA sky130_fd_pr__pfet_01v8 w=4.8 l=0.15
xptg2_1 BOT2 TRKB VIN VDDA sky130_fd_pr__pfet_01v8 w=4.8 l=0.15
xptg2_2 BOT2 TRKB VIN VDDA sky130_fd_pr__pfet_01v8 w=4.8 l=0.15
xptg2_3 BOT2 TRKB VIN VDDA sky130_fd_pr__pfet_01v8 w=4.8 l=0.15
xptg2_4 BOT2 TRKB VIN VDDA sky130_fd_pr__pfet_01v8 w=4.8 l=0.15
xndr2_0 BOT2 LO2 VREFN VSS sky130_fd_pr__nfet_01v8 w=1.5 l=0.15
xpdr2_0 BOT2 HIB2 VREFP VDDA sky130_fd_pr__pfet_01v8 w=3.75 l=0.15
xpdr2_1 BOT2 HIB2 VREFP VDDA sky130_fd_pr__pfet_01v8 w=3.75 l=0.15
xntg3_0 BOT3 TRK VIN VSS sky130_fd_pr__nfet_01v8 w=3 l=0.15
xntg3_1 BOT3 TRK VIN VSS sky130_fd_pr__nfet_01v8 w=3 l=0.15
xptg3_0 BOT3 TRKB VIN VDDA sky130_fd_pr__pfet_01v8 w=4 l=0.15
xptg3_1 BOT3 TRKB VIN VDDA sky130_fd_pr__pfet_01v8 w=4 l=0.15
xptg3_2 BOT3 TRKB VIN VDDA sky130_fd_pr__pfet_01v8 w=4 l=0.15
xndr3_0 BOT3 LO3 VREFN VSS sky130_fd_pr__nfet_01v8 w=1.5 l=0.15
xpdr3_0 BOT3 HIB3 VREFP VDDA sky130_fd_pr__pfet_01v8 w=3.75 l=0.15
xntg4_0 BOT4 TRK VIN VSS sky130_fd_pr__nfet_01v8 w=3 l=0.15
xptg4_0 BOT4 TRKB VIN VDDA sky130_fd_pr__pfet_01v8 w=3 l=0.15
xptg4_1 BOT4 TRKB VIN VDDA sky130_fd_pr__pfet_01v8 w=3 l=0.15
xndr4_0 BOT4 LO4 VREFN VSS sky130_fd_pr__nfet_01v8 w=1.5 l=0.15
xpdr4_0 BOT4 HIB4 VREFP VDDA sky130_fd_pr__pfet_01v8 w=1.88 l=0.15
xntg5_0 BOT5 TRK VIN VSS sky130_fd_pr__nfet_01v8 w=1.5 l=0.15
xptg5_0 BOT5 TRKB VIN VDDA sky130_fd_pr__pfet_01v8 w=3 l=0.15
xndr5_0 BOT5 LO5 VREFN VSS sky130_fd_pr__nfet_01v8 w=1.5 l=0.15
xpdr5_0 BOT5 HIB5 VREFP VDDA sky130_fd_pr__pfet_01v8 w=1.5 l=0.15
xntg6_0 BOT6 TRK VIN VSS sky130_fd_pr__nfet_01v8 w=1.5 l=0.15
xptg6_0 BOT6 TRKB VIN VDDA sky130_fd_pr__pfet_01v8 w=1.5 l=0.15
xndr6_0 BOT6 LO6 VREFN VSS sky130_fd_pr__nfet_01v8 w=1.8 l=0.15
xpdr6_0 BOT6 HIB6 VREFP VDDA sky130_fd_pr__pfet_01v8 w=1.5 l=0.15
xntg7_0 BOT7 TRK VIN VSS sky130_fd_pr__nfet_01v8 w=1.5 l=0.15
xptg7_0 BOT7 TRKB VIN VDDA sky130_fd_pr__pfet_01v8 w=1.5 l=0.15
xndr7_0 BOT7 LO7 VREFN VSS sky130_fd_pr__nfet_01v8 w=1.8 l=0.15
xpdr7_0 BOT7 HIB7 VREFP VDDA sky130_fd_pr__pfet_01v8 w=1.5 l=0.15
xntg8_0 BOT8 TRK VIN VSS sky130_fd_pr__nfet_01v8 w=1.5 l=0.15
xptg8_0 BOT8 TRKB VIN VDDA sky130_fd_pr__pfet_01v8 w=1.5 l=0.15
xndr8_0 BOT8 LO8 VREFN VSS sky130_fd_pr__nfet_01v8 w=1.5 l=0.15
xpdr8_0 BOT8 HIB8 VREFP VDDA sky130_fd_pr__pfet_01v8 w=1.5 l=0.15
xntg9_0 BOT9 TRK VIN VSS sky130_fd_pr__nfet_01v8 w=1.5 l=0.15
xptg9_0 BOT9 TRKB VIN VDDA sky130_fd_pr__pfet_01v8 w=1.5 l=0.15
xndr9_0 BOT9 LO9 VREFN VSS sky130_fd_pr__nfet_01v8 w=1.5 l=0.15
xpdr9_0 BOT9 HIB9 VREFP VDDA sky130_fd_pr__pfet_01v8 w=1.5 l=0.15
xntg10_0 BOT10 TRK VIN VSS sky130_fd_pr__nfet_01v8 w=1.5 l=0.15
xptg10_0 BOT10 TRKB VIN VDDA sky130_fd_pr__pfet_01v8 w=1.5 l=0.15
xndr10_0 BOT10 LO10 VREFN VSS sky130_fd_pr__nfet_01v8 w=1.5 l=0.15
.ends bank_side
